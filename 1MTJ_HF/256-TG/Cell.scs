* Crossbar one bit

simulator lang=spice

.include '45nm_LP.pm'
.include 'MTJT.spi'
.include 'TRANSGATE.spi'

.param cap = 51f

.param Vb = 1.6

.param Vnb = 0

.param Vvdd = Vb

.param res = 10k

.param Vhb = Vb/2

.param Vread = Vb

.param Tpwl = 0.7n
.param Tpbl = 0.7n
.param TpRead = 1.7n
.param TpWrite = 2.7n

Vwl1 WL1T Gnd PWL 0 'Vhb'
Vwl2 WL2T Gnd PWL 0 'Vhb'
Vwl3 WL3T Gnd PWL 0 'Vhb'
Vwl4 WL4T Gnd PWL 0 'Vhb'
Vwl5 WL5T Gnd PWL 0 'Vhb'
Vwl6 WL6T Gnd PWL 0 'Vhb'
Vwl7 WL7T Gnd PWL 0 'Vhb'
Vwl8 WL8T Gnd PWL 0 'Vhb'
Vwl9 WL9T Gnd PWL 0 'Vhb'
Vwl10 WL10T Gnd PWL 0 'Vhb'
Vwl11 WL11T Gnd PWL 0 'Vhb'
Vwl12 WL12T Gnd PWL 0 'Vhb'
Vwl13 WL13T Gnd PWL 0 'Vhb'
Vwl14 WL14T Gnd PWL 0 'Vhb'
Vwl15 WL15T Gnd PWL 0 'Vhb'
Vwl16 WL16T Gnd PWL 0 'Vhb' '(Tpwl-1p)' 'Vhb' 'Tpwl' 'Vb' '(Tpwl+0.3n-1p)' 'Vb' '(Tpwl+0.3n)' 'Vhb' 'TpRead' 'Vhb' '(TpRead+1p)' 'Vread' '(TpRead+0.3n-1p)' 'Vread' '(TpRead+0.3n)' 'Vhb' '(TpWrite-1p)' 'Vhb' '(TpWrite)' 'Vnb' '(TpWrite+0.5n-1p)' 'Vnb' '(TpWrite+0.5n)' 'Vhb' '(3n+Tpwl)' 'Vhb' '(3n+Tpwl+1p)' 'Vread' '(3n+Tpwl+0.3n-1p)' 'Vread' '(3n+Tpwl+0.3n)' 'Vhb'
Vwl17 WL17T Gnd PWL 0 'Vhb'
Vwl18 WL18T Gnd PWL 0 'Vhb'
Vwl19 WL19T Gnd PWL 0 'Vhb'
Vwl20 WL20T Gnd PWL 0 'Vhb'
Vwl21 WL21T Gnd PWL 0 'Vhb'
Vwl22 WL22T Gnd PWL 0 'Vhb'
Vwl23 WL23T Gnd PWL 0 'Vhb'
Vwl24 WL24T Gnd PWL 0 'Vhb'
Vwl25 WL25T Gnd PWL 0 'Vhb'
Vwl26 WL26T Gnd PWL 0 'Vhb'
Vwl27 WL27T Gnd PWL 0 'Vhb'
Vwl28 WL28T Gnd PWL 0 'Vhb'
Vwl29 WL29T Gnd PWL 0 'Vhb'
Vwl30 WL30T Gnd PWL 0 'Vhb'
Vwl31 WL31T Gnd PWL 0 'Vhb'
Vwl32 WL32T Gnd PWL 0 'Vhb'

Vbl1 BL1T Gnd PWL 0 'Vhb'
Vbl2 BL2T Gnd PWL 0 'Vhb'
Vbl3 BL3T Gnd PWL 0 'Vhb'
Vbl4 BL4T Gnd PWL 0 'Vhb' '(Tpbl-1p)' 'Vhb' 'Tpbl' 'Vnb' '(Tpbl+0.3n-1p)' 'Vnb' '(Tpbl+0.3n)' 'Vhb' '(TpWrite-1p)' 'Vhb' '(TpWrite)' 'Vb' '(TpWrite+0.5n-1p)' 'Vb' '(TpWrite+0.5n)' 'Vhb'
Vbl5 BL5T Gnd PWL 0 'Vhb'
Vbl6 BL6T Gnd PWL 0 'Vhb'
Vbl7 BL7T Gnd PWL 0 'Vhb'
Vbl8 BL8T Gnd PWL 0 'Vhb'

Vbl1en ENBl1 Gnd PWL 0 'Vnb'
Vbl2en ENBl2 Gnd PWL 0 'Vnb'
Vbl3en ENBl3 Gnd PWL 0 'Vnb'
Vbl4en ENBl4 Gnd PWL 0 'Vb'
Vbl5en ENBl5 Gnd PWL 0 'Vnb'
Vbl6en ENBl6 Gnd PWL 0 'Vnb'
Vbl7en ENBl7 Gnd PWL 0 'Vnb'
Vbl8en ENBl8 Gnd PWL 0 'Vnb'

Vwlen ENWl Gnd PWL 0 'Vnb'
Vwlen1 ENWl1 Gnd PWL 0 'Vb'

Vvdd Vdd Gnd 'Vb'

X514 WL1T WL1 ENWl Vdd Gnd TG
X515 WL2T WL2 ENWl Vdd Gnd TG
X516 WL3T WL3 ENWl Vdd Gnd TG
X517 WL4T WL4 ENWl Vdd Gnd TG
X518 WL5T WL5 ENWl Vdd Gnd TG
X519 WL6T WL6 ENWl Vdd Gnd TG
X520 WL7T WL7 ENWl Vdd Gnd TG
X521 WL8T WL8 ENWl Vdd Gnd TG
X522 WL9T WL9 ENWl Vdd Gnd TG
X523 WL10T WL10 ENWl Vdd Gnd TG
X524 WL11T WL11 ENWl Vdd Gnd TG
X525 WL12T WL12 ENWl Vdd Gnd TG
X526 WL13T WL13 ENWl Vdd Gnd TG
X527 WL14T WL14 ENWl Vdd Gnd TG
X528 WL15T WL15 ENWl Vdd Gnd TG
X529 WL16T WL16 ENWl1 Vdd Gnd TG
X530 WL17T WL17 ENWl Vdd Gnd TG
X531 WL18T WL18 ENWl Vdd Gnd TG
X532 WL19T WL19 ENWl Vdd Gnd TG
X533 WL20T WL20 ENWl Vdd Gnd TG
X534 WL21T WL21 ENWl Vdd Gnd TG
X535 WL22T WL22 ENWl Vdd Gnd TG
X536 WL23T WL23 ENWl Vdd Gnd TG
X537 WL24T WL24 ENWl Vdd Gnd TG
X538 WL25T WL25 ENWl Vdd Gnd TG
X539 WL26T WL26 ENWl Vdd Gnd TG
X540 WL27T WL27 ENWl Vdd Gnd TG
X541 WL28T WL28 ENWl Vdd Gnd TG
X542 WL29T WL29 ENWl Vdd Gnd TG
X543 WL30T WL30 ENWl Vdd Gnd TG
X544 WL31T WL31 ENWl Vdd Gnd TG
X545 WL32T WL32 ENWl Vdd Gnd TG

X599 BL1T BL1 ENBl1 Vdd Gnd TG
X590 BL2T BL2 ENBl2 Vdd Gnd TG
X591 BL3T BL3 ENBl3 Vdd Gnd TG
X592 BL4T BL4 ENBl4 Vdd Gnd TG
X593 BL5T BL5 ENBl5 Vdd Gnd TG
X594 BL6T BL6 ENBl6 Vdd Gnd TG
X595 BL7T BL7 ENBl7 Vdd Gnd TG
X596 BL8T BL8 ENBl8 Vdd Gnd TG

* Bitcell

X1 WL1 NM1 MTJT
Vtest1 BL1 NM1 0
X2 WL2 NM2 MTJT
Vtest2 BL1 NM2 0
X3 WL3 NM3 MTJT
Vtest3 BL1 NM3 0
X4 WL4 NM4 MTJT
Vtest4 BL1 NM4 0
X5 WL5 NM5 MTJT
Vtest5 BL1 NM5 0
X6 WL6 NM6 MTJT
Vtest6 BL1 NM6 0
X7 WL7 NM7 MTJT
Vtest7 BL1 NM7 0
X8 WL8 NM8 MTJT
Vtest8 BL1 NM8 0
X9 WL9 NM9 MTJT
Vtest9 BL1 NM9 0
X10 WL10 NM10 MTJT
Vtest10 BL1 NM10 0
X11 WL11 NM11 MTJT
Vtest11 BL1 NM11 0
X12 WL12 NM12 MTJT
Vtest12 BL1 NM12 0
X13 WL13 NM13 MTJT
Vtest13 BL1 NM13 0
X14 WL14 NM14 MTJT
Vtest14 BL1 NM14 0
X15 WL15 NM15 MTJT
Vtest15 BL1 NM15 0
X16 WL16 NM16 MTJT
Vtest16 BL1 NM16 0
X17 WL17 NM17 MTJT
Vtest17 BL1 NM17 0
X18 WL18 NM18 MTJT
Vtest18 BL1 NM18 0
X19 WL19 NM19 MTJT
Vtest19 BL1 NM19 0
X20 WL20 NM20 MTJT
Vtest20 BL1 NM20 0
X21 WL21 NM21 MTJT
Vtest21 BL1 NM21 0
X22 WL22 NM22 MTJT
Vtest22 BL1 NM22 0
X23 WL23 NM23 MTJT
Vtest23 BL1 NM23 0
X24 WL24 NM24 MTJT
Vtest24 BL1 NM24 0
X25 WL25 NM25 MTJT
Vtest25 BL1 NM25 0
X26 WL26 NM26 MTJT
Vtest26 BL1 NM26 0
X27 WL27 NM27 MTJT
Vtest27 BL1 NM27 0
X28 WL28 NM28 MTJT
Vtest28 BL1 NM28 0
X29 WL29 NM29 MTJT
Vtest29 BL1 NM29 0
X30 WL30 NM30 MTJT
Vtest30 BL1 NM30 0
X31 WL31 NM31 MTJT
Vtest31 BL1 NM31 0
X32 WL32 NM32 MTJT
Vtest32 BL1 NM32 0
X33 WL1 NM33 MTJT
Vtest33 BL2 NM33 0
X34 WL2 NM34 MTJT
Vtest34 BL2 NM34 0
X35 WL3 NM35 MTJT
Vtest35 BL2 NM35 0
X36 WL4 NM36 MTJT
Vtest36 BL2 NM36 0
X37 WL5 NM37 MTJT
Vtest37 BL2 NM37 0
X38 WL6 NM38 MTJT
Vtest38 BL2 NM38 0
X39 WL7 NM39 MTJT
Vtest39 BL2 NM39 0
X40 WL8 NM40 MTJT
Vtest40 BL2 NM40 0
X41 WL9 NM41 MTJT
Vtest41 BL2 NM41 0
X42 WL10 NM42 MTJT
Vtest42 BL2 NM42 0
X43 WL11 NM43 MTJT
Vtest43 BL2 NM43 0
X44 WL12 NM44 MTJT
Vtest44 BL2 NM44 0
X45 WL13 NM45 MTJT
Vtest45 BL2 NM45 0
X46 WL14 NM46 MTJT
Vtest46 BL2 NM46 0
X47 WL15 NM47 MTJT
Vtest47 BL2 NM47 0
X48 WL16 NM48 MTJT
Vtest48 BL2 NM48 0
X49 WL17 NM49 MTJT
Vtest49 BL2 NM49 0
X50 WL18 NM50 MTJT
Vtest50 BL2 NM50 0
X51 WL19 NM51 MTJT
Vtest51 BL2 NM51 0
X52 WL20 NM52 MTJT
Vtest52 BL2 NM52 0
X53 WL21 NM53 MTJT
Vtest53 BL2 NM53 0
X54 WL22 NM54 MTJT
Vtest54 BL2 NM54 0
X55 WL23 NM55 MTJT
Vtest55 BL2 NM55 0
X56 WL24 NM56 MTJT
Vtest56 BL2 NM56 0
X57 WL25 NM57 MTJT
Vtest57 BL2 NM57 0
X58 WL26 NM58 MTJT
Vtest58 BL2 NM58 0
X59 WL27 NM59 MTJT
Vtest59 BL2 NM59 0
X60 WL28 NM60 MTJT
Vtest60 BL2 NM60 0
X61 WL29 NM61 MTJT
Vtest61 BL2 NM61 0
X62 WL30 NM62 MTJT
Vtest62 BL2 NM62 0
X63 WL31 NM63 MTJT
Vtest63 BL2 NM63 0
X64 WL32 NM64 MTJT
Vtest64 BL2 NM64 0
X65 WL1 NM65 MTJT
Vtest65 BL3 NM65 0
X66 WL2 NM66 MTJT
Vtest66 BL3 NM66 0
X67 WL3 NM67 MTJT
Vtest67 BL3 NM67 0
X68 WL4 NM68 MTJT
Vtest68 BL3 NM68 0
X69 WL5 NM69 MTJT
Vtest69 BL3 NM69 0
X70 WL6 NM70 MTJT
Vtest70 BL3 NM70 0
X71 WL7 NM71 MTJT
Vtest71 BL3 NM71 0
X72 WL8 NM72 MTJT
Vtest72 BL3 NM72 0
X73 WL9 NM73 MTJT
Vtest73 BL3 NM73 0
X74 WL10 NM74 MTJT
Vtest74 BL3 NM74 0
X75 WL11 NM75 MTJT
Vtest75 BL3 NM75 0
X76 WL12 NM76 MTJT
Vtest76 BL3 NM76 0
X77 WL13 NM77 MTJT
Vtest77 BL3 NM77 0
X78 WL14 NM78 MTJT
Vtest78 BL3 NM78 0
X79 WL15 NM79 MTJT
Vtest79 BL3 NM79 0
X80 WL16 NM80 MTJT
Vtest80 BL3 NM80 0
X81 WL17 NM81 MTJT
Vtest81 BL3 NM81 0
X82 WL18 NM82 MTJT
Vtest82 BL3 NM82 0
X83 WL19 NM83 MTJT
Vtest83 BL3 NM83 0
X84 WL20 NM84 MTJT
Vtest84 BL3 NM84 0
X85 WL21 NM85 MTJT
Vtest85 BL3 NM85 0
X86 WL22 NM86 MTJT
Vtest86 BL3 NM86 0
X87 WL23 NM87 MTJT
Vtest87 BL3 NM87 0
X88 WL24 NM88 MTJT
Vtest88 BL3 NM88 0
X89 WL25 NM89 MTJT
Vtest89 BL3 NM89 0
X90 WL26 NM90 MTJT
Vtest90 BL3 NM90 0
X91 WL27 NM91 MTJT
Vtest91 BL3 NM91 0
X92 WL28 NM92 MTJT
Vtest92 BL3 NM92 0
X93 WL29 NM93 MTJT
Vtest93 BL3 NM93 0
X94 WL30 NM94 MTJT
Vtest94 BL3 NM94 0
X95 WL31 NM95 MTJT
Vtest95 BL3 NM95 0
X96 WL32 NM96 MTJT
Vtest96 BL3 NM96 0
X97 WL1 NM97 MTJT
Vtest97 BL4 NM97 0
X98 WL2 NM98 MTJT
Vtest98 BL4 NM98 0
X99 WL3 NM99 MTJT
Vtest99 BL4 NM99 0
X100 WL4 NM100 MTJT
Vtest100 BL4 NM100 0
X101 WL5 NM101 MTJT
Vtest101 BL4 NM101 0
X102 WL6 NM102 MTJT
Vtest102 BL4 NM102 0
X103 WL7 NM103 MTJT
Vtest103 BL4 NM103 0
X104 WL8 NM104 MTJT
Vtest104 BL4 NM104 0
X105 WL9 NM105 MTJT
Vtest105 BL4 NM105 0
X106 WL10 NM106 MTJT
Vtest106 BL4 NM106 0
X107 WL11 NM107 MTJT
Vtest107 BL4 NM107 0
X108 WL12 NM108 MTJT
Vtest108 BL4 NM108 0
X109 WL13 NM109 MTJT
Vtest109 BL4 NM109 0
X110 WL14 NM110 MTJT
Vtest110 BL4 NM110 0
X111 WL15 NM111 MTJT
Vtest111 BL4 NM111 0
X112 WL16 NM112 MTJT
Vtest112 BL4 NM112 0
X113 WL17 NM113 MTJT
Vtest113 BL4 NM113 0
X114 WL18 NM114 MTJT
Vtest114 BL4 NM114 0
X115 WL19 NM115 MTJT
Vtest115 BL4 NM115 0
X116 WL20 NM116 MTJT
Vtest116 BL4 NM116 0
X117 WL21 NM117 MTJT
Vtest117 BL4 NM117 0
X118 WL22 NM118 MTJT
Vtest118 BL4 NM118 0
X119 WL23 NM119 MTJT
Vtest119 BL4 NM119 0
X120 WL24 NM120 MTJT
Vtest120 BL4 NM120 0
X121 WL25 NM121 MTJT
Vtest121 BL4 NM121 0
X122 WL26 NM122 MTJT
Vtest122 BL4 NM122 0
X123 WL27 NM123 MTJT
Vtest123 BL4 NM123 0
X124 WL28 NM124 MTJT
Vtest124 BL4 NM124 0
X125 WL29 NM125 MTJT
Vtest125 BL4 NM125 0
X126 WL30 NM126 MTJT
Vtest126 BL4 NM126 0
X127 WL31 NM127 MTJT
Vtest127 BL4 NM127 0
X128 WL32 NM128 MTJT
Vtest128 BL4 NM128 0
X129 WL1 NM129 MTJT
Vtest129 BL5 NM129 0
X130 WL2 NM130 MTJT
Vtest130 BL5 NM130 0
X131 WL3 NM131 MTJT
Vtest131 BL5 NM131 0
X132 WL4 NM132 MTJT
Vtest132 BL5 NM132 0
X133 WL5 NM133 MTJT
Vtest133 BL5 NM133 0
X134 WL6 NM134 MTJT
Vtest134 BL5 NM134 0
X135 WL7 NM135 MTJT
Vtest135 BL5 NM135 0
X136 WL8 NM136 MTJT
Vtest136 BL5 NM136 0
X137 WL9 NM137 MTJT
Vtest137 BL5 NM137 0
X138 WL10 NM138 MTJT
Vtest138 BL5 NM138 0
X139 WL11 NM139 MTJT
Vtest139 BL5 NM139 0
X140 WL12 NM140 MTJT
Vtest140 BL5 NM140 0
X141 WL13 NM141 MTJT
Vtest141 BL5 NM141 0
X142 WL14 NM142 MTJT
Vtest142 BL5 NM142 0
X143 WL15 NM143 MTJT
Vtest143 BL5 NM143 0
X144 WL16 NM144 MTJT
Vtest144 BL5 NM144 0
X145 WL17 NM145 MTJT
Vtest145 BL5 NM145 0
X146 WL18 NM146 MTJT
Vtest146 BL5 NM146 0
X147 WL19 NM147 MTJT
Vtest147 BL5 NM147 0
X148 WL20 NM148 MTJT
Vtest148 BL5 NM148 0
X149 WL21 NM149 MTJT
Vtest149 BL5 NM149 0
X150 WL22 NM150 MTJT
Vtest150 BL5 NM150 0
X151 WL23 NM151 MTJT
Vtest151 BL5 NM151 0
X152 WL24 NM152 MTJT
Vtest152 BL5 NM152 0
X153 WL25 NM153 MTJT
Vtest153 BL5 NM153 0
X154 WL26 NM154 MTJT
Vtest154 BL5 NM154 0
X155 WL27 NM155 MTJT
Vtest155 BL5 NM155 0
X156 WL28 NM156 MTJT
Vtest156 BL5 NM156 0
X157 WL29 NM157 MTJT
Vtest157 BL5 NM157 0
X158 WL30 NM158 MTJT
Vtest158 BL5 NM158 0
X159 WL31 NM159 MTJT
Vtest159 BL5 NM159 0
X160 WL32 NM160 MTJT
Vtest160 BL5 NM160 0
X161 WL1 NM161 MTJT
Vtest161 BL6 NM161 0
X162 WL2 NM162 MTJT
Vtest162 BL6 NM162 0
X163 WL3 NM163 MTJT
Vtest163 BL6 NM163 0
X164 WL4 NM164 MTJT
Vtest164 BL6 NM164 0
X165 WL5 NM165 MTJT
Vtest165 BL6 NM165 0
X166 WL6 NM166 MTJT
Vtest166 BL6 NM166 0
X167 WL7 NM167 MTJT
Vtest167 BL6 NM167 0
X168 WL8 NM168 MTJT
Vtest168 BL6 NM168 0
X169 WL9 NM169 MTJT
Vtest169 BL6 NM169 0
X170 WL10 NM170 MTJT
Vtest170 BL6 NM170 0
X171 WL11 NM171 MTJT
Vtest171 BL6 NM171 0
X172 WL12 NM172 MTJT
Vtest172 BL6 NM172 0
X173 WL13 NM173 MTJT
Vtest173 BL6 NM173 0
X174 WL14 NM174 MTJT
Vtest174 BL6 NM174 0
X175 WL15 NM175 MTJT
Vtest175 BL6 NM175 0
X176 WL16 NM176 MTJT
Vtest176 BL6 NM176 0
X177 WL17 NM177 MTJT
Vtest177 BL6 NM177 0
X178 WL18 NM178 MTJT
Vtest178 BL6 NM178 0
X179 WL19 NM179 MTJT
Vtest179 BL6 NM179 0
X180 WL20 NM180 MTJT
Vtest180 BL6 NM180 0
X181 WL21 NM181 MTJT
Vtest181 BL6 NM181 0
X182 WL22 NM182 MTJT
Vtest182 BL6 NM182 0
X183 WL23 NM183 MTJT
Vtest183 BL6 NM183 0
X184 WL24 NM184 MTJT
Vtest184 BL6 NM184 0
X185 WL25 NM185 MTJT
Vtest185 BL6 NM185 0
X186 WL26 NM186 MTJT
Vtest186 BL6 NM186 0
X187 WL27 NM187 MTJT
Vtest187 BL6 NM187 0
X188 WL28 NM188 MTJT
Vtest188 BL6 NM188 0
X189 WL29 NM189 MTJT
Vtest189 BL6 NM189 0
X190 WL30 NM190 MTJT
Vtest190 BL6 NM190 0
X191 WL31 NM191 MTJT
Vtest191 BL6 NM191 0
X192 WL32 NM192 MTJT
Vtest192 BL6 NM192 0
X193 WL1 NM193 MTJT
Vtest193 BL7 NM193 0
X194 WL2 NM194 MTJT
Vtest194 BL7 NM194 0
X195 WL3 NM195 MTJT
Vtest195 BL7 NM195 0
X196 WL4 NM196 MTJT
Vtest196 BL7 NM196 0
X197 WL5 NM197 MTJT
Vtest197 BL7 NM197 0
X198 WL6 NM198 MTJT
Vtest198 BL7 NM198 0
X199 WL7 NM199 MTJT
Vtest199 BL7 NM199 0
X200 WL8 NM200 MTJT
Vtest200 BL7 NM200 0
X201 WL9 NM201 MTJT
Vtest201 BL7 NM201 0
X202 WL10 NM202 MTJT
Vtest202 BL7 NM202 0
X203 WL11 NM203 MTJT
Vtest203 BL7 NM203 0
X204 WL12 NM204 MTJT
Vtest204 BL7 NM204 0
X205 WL13 NM205 MTJT
Vtest205 BL7 NM205 0
X206 WL14 NM206 MTJT
Vtest206 BL7 NM206 0
X207 WL15 NM207 MTJT
Vtest207 BL7 NM207 0
X208 WL16 NM208 MTJT
Vtest208 BL7 NM208 0
X209 WL17 NM209 MTJT
Vtest209 BL7 NM209 0
X210 WL18 NM210 MTJT
Vtest210 BL7 NM210 0
X211 WL19 NM211 MTJT
Vtest211 BL7 NM211 0
X212 WL20 NM212 MTJT
Vtest212 BL7 NM212 0
X213 WL21 NM213 MTJT
Vtest213 BL7 NM213 0
X214 WL22 NM214 MTJT
Vtest214 BL7 NM214 0
X215 WL23 NM215 MTJT
Vtest215 BL7 NM215 0
X216 WL24 NM216 MTJT
Vtest216 BL7 NM216 0
X217 WL25 NM217 MTJT
Vtest217 BL7 NM217 0
X218 WL26 NM218 MTJT
Vtest218 BL7 NM218 0
X219 WL27 NM219 MTJT
Vtest219 BL7 NM219 0
X220 WL28 NM220 MTJT
Vtest220 BL7 NM220 0
X221 WL29 NM221 MTJT
Vtest221 BL7 NM221 0
X222 WL30 NM222 MTJT
Vtest222 BL7 NM222 0
X223 WL31 NM223 MTJT
Vtest223 BL7 NM223 0
X224 WL32 NM224 MTJT
Vtest224 BL7 NM224 0
X225 WL1 NM225 MTJT
Vtest225 BL8 NM225 0
X226 WL2 NM226 MTJT
Vtest226 BL8 NM226 0
X227 WL3 NM227 MTJT
Vtest227 BL8 NM227 0
X228 WL4 NM228 MTJT
Vtest228 BL8 NM228 0
X229 WL5 NM229 MTJT
Vtest229 BL8 NM229 0
X230 WL6 NM230 MTJT
Vtest230 BL8 NM230 0
X231 WL7 NM231 MTJT
Vtest231 BL8 NM231 0
X232 WL8 NM232 MTJT
Vtest232 BL8 NM232 0
X233 WL9 NM233 MTJT
Vtest233 BL8 NM233 0
X234 WL10 NM234 MTJT
Vtest234 BL8 NM234 0
X235 WL11 NM235 MTJT
Vtest235 BL8 NM235 0
X236 WL12 NM236 MTJT
Vtest236 BL8 NM236 0
X237 WL13 NM237 MTJT
Vtest237 BL8 NM237 0
X238 WL14 NM238 MTJT
Vtest238 BL8 NM238 0
X239 WL15 NM239 MTJT
Vtest239 BL8 NM239 0
X240 WL16 NM240 MTJT
Vtest240 BL8 NM240 0
X241 WL17 NM241 MTJT
Vtest241 BL8 NM241 0
X242 WL18 NM242 MTJT
Vtest242 BL8 NM242 0
X243 WL19 NM243 MTJT
Vtest243 BL8 NM243 0
X244 WL20 NM244 MTJT
Vtest244 BL8 NM244 0
X245 WL21 NM245 MTJT
Vtest245 BL8 NM245 0
X246 WL22 NM246 MTJT
Vtest246 BL8 NM246 0
X247 WL23 NM247 MTJT
Vtest247 BL8 NM247 0
X248 WL24 NM248 MTJT
Vtest248 BL8 NM248 0
X249 WL25 NM249 MTJT
Vtest249 BL8 NM249 0
X250 WL26 NM250 MTJT
Vtest250 BL8 NM250 0
X251 WL27 NM251 MTJT
Vtest251 BL8 NM251 0
X252 WL28 NM252 MTJT
Vtest252 BL8 NM252 0
X253 WL29 NM253 MTJT
Vtest253 BL8 NM253 0
X254 WL30 NM254 MTJT
Vtest254 BL8 NM254 0
X255 WL31 NM255 MTJT
Vtest255 BL8 NM255 0
X256 WL32 NM256 MTJT
Vtest256 BL8 NM256 0

* Bitlines Capacitance

Cbl1 BL1 Gnd 'cap'
Cbl2 BL2 Gnd 'cap'
Cbl3 BL3 Gnd 'cap'
Cbl4 BL4 Gnd 'cap'
Cbl5 BL5 Gnd 'cap'
Cbl6 BL6 Gnd 'cap'
Cbl7 BL7 Gnd 'cap'
Cbl8 BL8 Gnd 'cap'

R1 BL1 Gnd 'res'
R2 BL2 Gnd 'res'
R3 BL3 Gnd 'res'
R4 BL4 Gnd 'res'
R5 BL5 Gnd 'res'
R6 BL6 Gnd 'res'
R7 BL7 Gnd 'res'
R8 BL8 Gnd 'res'

Cbl11 WL1 Gnd 'cap'
Cbl12 WL2 Gnd 'cap'
Cbl13 WL3 Gnd 'cap'
Cbl14 WL4 Gnd 'cap'
Cbl15 WL5 Gnd 'cap'
Cbl16 WL6 Gnd 'cap'
Cbl17 WL7 Gnd 'cap'
Cbl18 WL8 Gnd 'cap'
Cbl19 WL9 Gnd 'cap'
Cbl20 WL10 Gnd 'cap'
Cbl21 WL11 Gnd 'cap'
Cbl22 WL12 Gnd 'cap'
Cbl23 WL13 Gnd 'cap'
Cbl24 WL14 Gnd 'cap'
Cbl25 WL15 Gnd 'cap'
Cbl26 WL16 Gnd 'cap'
Cbl27 WL17 Gnd 'cap'
Cbl28 WL18 Gnd 'cap'
Cbl29 WL19 Gnd 'cap'
Cbl30 WL20 Gnd 'cap'
Cbl31 WL21 Gnd 'cap'
Cbl32 WL22 Gnd 'cap'
Cbl33 WL23 Gnd 'cap'
Cbl34 WL24 Gnd 'cap'
Cbl35 WL25 Gnd 'cap'
Cbl36 WL26 Gnd 'cap'
Cbl37 WL27 Gnd 'cap'
Cbl38 WL28 Gnd 'cap'
Cbl39 WL29 Gnd 'cap'
Cbl40 WL30 Gnd 'cap'
Cbl41 WL31 Gnd 'cap'
Cbl42 WL32 Gnd 'cap'

.TRAN 1p 10n

.option rawfmt="psfbin" cmin=12f
