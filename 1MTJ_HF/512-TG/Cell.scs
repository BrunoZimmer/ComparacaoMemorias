* Crossbar one bit

simulator lang=spice

.include '45nm_LP.pm'
.include 'MTJT.spi'
.include 'TRANSGATE.spi'

.param cap = 51f

.param Vb = 1.6
.param Vvdd = Vb

.param Vnb = 0

.param Vhb = Vb/2

.param Vread = Vb

.param Tpwl = 0.7n
.param Tpbl = 0.7n
.param TpRead = 1.7n
.param TpWrite = 2.7n

.param res = 10k

Vwl1 WL1T Gnd PWL 0 'Vhb'
Vwl2 WL2T Gnd PWL 0 'Vhb'
Vwl3 WL3T Gnd PWL 0 'Vhb'
Vwl4 WL4T Gnd PWL 0 'Vhb'
Vwl5 WL5T Gnd PWL 0 'Vhb'
Vwl6 WL6T Gnd PWL 0 'Vhb'
Vwl7 WL7T Gnd PWL 0 'Vhb'
Vwl8 WL8T Gnd PWL 0 'Vhb'
Vwl9 WL9T Gnd PWL 0 'Vhb'
Vwl10 WL10T Gnd PWL 0 'Vhb'
Vwl11 WL11T Gnd PWL 0 'Vhb'
Vwl12 WL12T Gnd PWL 0 'Vhb'
Vwl13 WL13T Gnd PWL 0 'Vhb'
Vwl14 WL14T Gnd PWL 0 'Vhb'
Vwl15 WL15T Gnd PWL 0 'Vhb'
Vwl16 WL16T Gnd PWL 0 'Vhb'
Vwl17 WL17T Gnd PWL 0 'Vhb'
Vwl18 WL18T Gnd PWL 0 'Vhb'
Vwl19 WL19T Gnd PWL 0 'Vhb'
Vwl20 WL20T Gnd PWL 0 'Vhb'
Vwl21 WL21T Gnd PWL 0 'Vhb'
Vwl22 WL22T Gnd PWL 0 'Vhb'
Vwl23 WL23T Gnd PWL 0 'Vhb'
Vwl24 WL24T Gnd PWL 0 'Vhb'
Vwl25 WL25T Gnd PWL 0 'Vhb'
Vwl26 WL26T Gnd PWL 0 'Vhb'
Vwl27 WL27T Gnd PWL 0 'Vhb'
Vwl28 WL28T Gnd PWL 0 'Vhb'
Vwl29 WL29T Gnd PWL 0 'Vhb'
Vwl30 WL30T Gnd PWL 0 'Vhb'
Vwl31 WL31T Gnd PWL 0 'Vhb'
Vwl32 WL32T Gnd PWL 0 'Vhb' '(Tpwl-1p)' 'Vhb' 'Tpwl' 'Vb' '(Tpwl+0.3n-1p)' 'Vb' '(Tpwl+0.3n)' 'Vhb' 'TpRead' 'Vhb' '(TpRead+1p)' 'Vread' '(TpRead+0.3n-1p)' 'Vread' '(TpRead+0.3n)' 'Vhb' '(TpWrite-1p)' 'Vhb' '(TpWrite)' 'Vnb' '(TpWrite+0.5n-1p)' 'Vnb' '(TpWrite+0.5n)' 'Vhb' '(3n+Tpwl)' 'Vhb' '(3n+Tpwl+1p)' 'Vread' '(3n+Tpwl+0.3n-1p)' 'Vread' '(3n+Tpwl+0.3n)' 'Vhb'
Vwl33 WL33T Gnd PWL 0 'Vhb'
Vwl34 WL34T Gnd PWL 0 'Vhb'
Vwl35 WL35T Gnd PWL 0 'Vhb'
Vwl36 WL36T Gnd PWL 0 'Vhb'
Vwl37 WL37T Gnd PWL 0 'Vhb'
Vwl38 WL38T Gnd PWL 0 'Vhb'
Vwl39 WL39T Gnd PWL 0 'Vhb'
Vwl40 WL40T Gnd PWL 0 'Vhb'
Vwl41 WL41T Gnd PWL 0 'Vhb'
Vwl42 WL42T Gnd PWL 0 'Vhb'
Vwl43 WL43T Gnd PWL 0 'Vhb'
Vwl44 WL44T Gnd PWL 0 'Vhb'
Vwl45 WL45T Gnd PWL 0 'Vhb'
Vwl46 WL46T Gnd PWL 0 'Vhb'
Vwl47 WL47T Gnd PWL 0 'Vhb'
Vwl48 WL48T Gnd PWL 0 'Vhb'
Vwl49 WL49T Gnd PWL 0 'Vhb'
Vwl50 WL50T Gnd PWL 0 'Vhb'
Vwl51 WL51T Gnd PWL 0 'Vhb'
Vwl52 WL52T Gnd PWL 0 'Vhb'
Vwl53 WL53T Gnd PWL 0 'Vhb'
Vwl54 WL54T Gnd PWL 0 'Vhb'
Vwl55 WL55T Gnd PWL 0 'Vhb'
Vwl56 WL56T Gnd PWL 0 'Vhb'
Vwl57 WL57T Gnd PWL 0 'Vhb'
Vwl58 WL58T Gnd PWL 0 'Vhb'
Vwl59 WL59T Gnd PWL 0 'Vhb'
Vwl60 WL60T Gnd PWL 0 'Vhb'
Vwl61 WL61T Gnd PWL 0 'Vhb'
Vwl62 WL62T Gnd PWL 0 'Vhb'
Vwl63 WL63T Gnd PWL 0 'Vhb'
Vwl64 WL64T Gnd PWL 0 'Vhb'

Vbl1 BL1T Gnd PWL 0 'Vhb'
Vbl2 BL2T Gnd PWL 0 'Vhb'
Vbl3 BL3T Gnd PWL 0 'Vhb'
Vbl4 BL4T Gnd PWL 0 'Vhb' '(Tpbl-1p)' 'Vhb' 'Tpbl' 'Vnb' '(Tpbl+0.3n-1p)' 'Vnb' '(Tpbl+0.3n)' 'Vhb' '(TpWrite-1p)' 'Vhb' '(TpWrite)' 'Vb' '(TpWrite+0.5n-1p)' 'Vb' '(TpWrite+0.5n)' 'Vhb'
Vbl5 BL5T Gnd PWL 0 'Vhb'
Vbl6 BL6T Gnd PWL 0 'Vhb'
Vbl7 BL7T Gnd PWL 0 'Vhb'
Vbl8 BL8T Gnd PWL 0 'Vhb'

Vbl1en ENBl1 Gnd PWL 0 'Vnb'
Vbl2en ENBl2 Gnd PWL 0 'Vnb'
Vbl3en ENBl3 Gnd PWL 0 'Vnb'
Vbl4en ENBl4 Gnd PWL 0 'Vb'
Vbl5en ENBl5 Gnd PWL 0 'Vnb'
Vbl6en ENBl6 Gnd PWL 0 'Vnb'
Vbl7en ENBl7 Gnd PWL 0 'Vnb'
Vbl8en ENBl8 Gnd PWL 0 'Vnb'

Vwlen ENWl Gnd PWL 0 'Vnb'
Vwlen1 ENWl1 Gnd PWL 0 'Vb'

Vvdd Vdd Gnd 'Vb'

* Bitcell

X1 WL1 NM1 MTJT
Vtest1 BL1 NM1 0
X2 WL2 NM2 MTJT
Vtest2 BL1 NM2 0
X3 WL3 NM3 MTJT
Vtest3 BL1 NM3 0
X4 WL4 NM4 MTJT
Vtest4 BL1 NM4 0
X5 WL5 NM5 MTJT
Vtest5 BL1 NM5 0
X6 WL6 NM6 MTJT
Vtest6 BL1 NM6 0
X7 WL7 NM7 MTJT
Vtest7 BL1 NM7 0
X8 WL8 NM8 MTJT
Vtest8 BL1 NM8 0
X9 WL9 NM9 MTJT
Vtest9 BL1 NM9 0
X10 WL10 NM10 MTJT
Vtest10 BL1 NM10 0
X11 WL11 NM11 MTJT
Vtest11 BL1 NM11 0
X12 WL12 NM12 MTJT
Vtest12 BL1 NM12 0
X13 WL13 NM13 MTJT
Vtest13 BL1 NM13 0
X14 WL14 NM14 MTJT
Vtest14 BL1 NM14 0
X15 WL15 NM15 MTJT
Vtest15 BL1 NM15 0
X16 WL16 NM16 MTJT
Vtest16 BL1 NM16 0
X17 WL17 NM17 MTJT
Vtest17 BL1 NM17 0
X18 WL18 NM18 MTJT
Vtest18 BL1 NM18 0
X19 WL19 NM19 MTJT
Vtest19 BL1 NM19 0
X20 WL20 NM20 MTJT
Vtest20 BL1 NM20 0
X21 WL21 NM21 MTJT
Vtest21 BL1 NM21 0
X22 WL22 NM22 MTJT
Vtest22 BL1 NM22 0
X23 WL23 NM23 MTJT
Vtest23 BL1 NM23 0
X24 WL24 NM24 MTJT
Vtest24 BL1 NM24 0
X25 WL25 NM25 MTJT
Vtest25 BL1 NM25 0
X26 WL26 NM26 MTJT
Vtest26 BL1 NM26 0
X27 WL27 NM27 MTJT
Vtest27 BL1 NM27 0
X28 WL28 NM28 MTJT
Vtest28 BL1 NM28 0
X29 WL29 NM29 MTJT
Vtest29 BL1 NM29 0
X30 WL30 NM30 MTJT
Vtest30 BL1 NM30 0
X31 WL31 NM31 MTJT
Vtest31 BL1 NM31 0
X32 WL32 NM32 MTJT
Vtest32 BL1 NM32 0
X33 WL33 NM33 MTJT
Vtest33 BL1 NM33 0
X34 WL34 NM34 MTJT
Vtest34 BL1 NM34 0
X35 WL35 NM35 MTJT
Vtest35 BL1 NM35 0
X36 WL36 NM36 MTJT
Vtest36 BL1 NM36 0
X37 WL37 NM37 MTJT
Vtest37 BL1 NM37 0
X38 WL38 NM38 MTJT
Vtest38 BL1 NM38 0
X39 WL39 NM39 MTJT
Vtest39 BL1 NM39 0
X40 WL40 NM40 MTJT
Vtest40 BL1 NM40 0
X41 WL41 NM41 MTJT
Vtest41 BL1 NM41 0
X42 WL42 NM42 MTJT
Vtest42 BL1 NM42 0
X43 WL43 NM43 MTJT
Vtest43 BL1 NM43 0
X44 WL44 NM44 MTJT
Vtest44 BL1 NM44 0
X45 WL45 NM45 MTJT
Vtest45 BL1 NM45 0
X46 WL46 NM46 MTJT
Vtest46 BL1 NM46 0
X47 WL47 NM47 MTJT
Vtest47 BL1 NM47 0
X48 WL48 NM48 MTJT
Vtest48 BL1 NM48 0
X49 WL49 NM49 MTJT
Vtest49 BL1 NM49 0
X50 WL50 NM50 MTJT
Vtest50 BL1 NM50 0
X51 WL51 NM51 MTJT
Vtest51 BL1 NM51 0
X52 WL52 NM52 MTJT
Vtest52 BL1 NM52 0
X53 WL53 NM53 MTJT
Vtest53 BL1 NM53 0
X54 WL54 NM54 MTJT
Vtest54 BL1 NM54 0
X55 WL55 NM55 MTJT
Vtest55 BL1 NM55 0
X56 WL56 NM56 MTJT
Vtest56 BL1 NM56 0
X57 WL57 NM57 MTJT
Vtest57 BL1 NM57 0
X58 WL58 NM58 MTJT
Vtest58 BL1 NM58 0
X59 WL59 NM59 MTJT
Vtest59 BL1 NM59 0
X60 WL60 NM60 MTJT
Vtest60 BL1 NM60 0
X61 WL61 NM61 MTJT
Vtest61 BL1 NM61 0
X62 WL62 NM62 MTJT
Vtest62 BL1 NM62 0
X63 WL63 NM63 MTJT
Vtest63 BL1 NM63 0
X64 WL64 NM64 MTJT
Vtest64 BL1 NM64 0
X65 WL1 NM65 MTJT
Vtest65 BL2 NM65 0
X66 WL2 NM66 MTJT
Vtest66 BL2 NM66 0
X67 WL3 NM67 MTJT
Vtest67 BL2 NM67 0
X68 WL4 NM68 MTJT
Vtest68 BL2 NM68 0
X69 WL5 NM69 MTJT
Vtest69 BL2 NM69 0
X70 WL6 NM70 MTJT
Vtest70 BL2 NM70 0
X71 WL7 NM71 MTJT
Vtest71 BL2 NM71 0
X72 WL8 NM72 MTJT
Vtest72 BL2 NM72 0
X73 WL9 NM73 MTJT
Vtest73 BL2 NM73 0
X74 WL10 NM74 MTJT
Vtest74 BL2 NM74 0
X75 WL11 NM75 MTJT
Vtest75 BL2 NM75 0
X76 WL12 NM76 MTJT
Vtest76 BL2 NM76 0
X77 WL13 NM77 MTJT
Vtest77 BL2 NM77 0
X78 WL14 NM78 MTJT
Vtest78 BL2 NM78 0
X79 WL15 NM79 MTJT
Vtest79 BL2 NM79 0
X80 WL16 NM80 MTJT
Vtest80 BL2 NM80 0
X81 WL17 NM81 MTJT
Vtest81 BL2 NM81 0
X82 WL18 NM82 MTJT
Vtest82 BL2 NM82 0
X83 WL19 NM83 MTJT
Vtest83 BL2 NM83 0
X84 WL20 NM84 MTJT
Vtest84 BL2 NM84 0
X85 WL21 NM85 MTJT
Vtest85 BL2 NM85 0
X86 WL22 NM86 MTJT
Vtest86 BL2 NM86 0
X87 WL23 NM87 MTJT
Vtest87 BL2 NM87 0
X88 WL24 NM88 MTJT
Vtest88 BL2 NM88 0
X89 WL25 NM89 MTJT
Vtest89 BL2 NM89 0
X90 WL26 NM90 MTJT
Vtest90 BL2 NM90 0
X91 WL27 NM91 MTJT
Vtest91 BL2 NM91 0
X92 WL28 NM92 MTJT
Vtest92 BL2 NM92 0
X93 WL29 NM93 MTJT
Vtest93 BL2 NM93 0
X94 WL30 NM94 MTJT
Vtest94 BL2 NM94 0
X95 WL31 NM95 MTJT
Vtest95 BL2 NM95 0
X96 WL32 NM96 MTJT
Vtest96 BL2 NM96 0
X97 WL33 NM97 MTJT
Vtest97 BL2 NM97 0
X98 WL34 NM98 MTJT
Vtest98 BL2 NM98 0
X99 WL35 NM99 MTJT
Vtest99 BL2 NM99 0
X100 WL36 NM100 MTJT
Vtest100 BL2 NM100 0
X101 WL37 NM101 MTJT
Vtest101 BL2 NM101 0
X102 WL38 NM102 MTJT
Vtest102 BL2 NM102 0
X103 WL39 NM103 MTJT
Vtest103 BL2 NM103 0
X104 WL40 NM104 MTJT
Vtest104 BL2 NM104 0
X105 WL41 NM105 MTJT
Vtest105 BL2 NM105 0
X106 WL42 NM106 MTJT
Vtest106 BL2 NM106 0
X107 WL43 NM107 MTJT
Vtest107 BL2 NM107 0
X108 WL44 NM108 MTJT
Vtest108 BL2 NM108 0
X109 WL45 NM109 MTJT
Vtest109 BL2 NM109 0
X110 WL46 NM110 MTJT
Vtest110 BL2 NM110 0
X111 WL47 NM111 MTJT
Vtest111 BL2 NM111 0
X112 WL48 NM112 MTJT
Vtest112 BL2 NM112 0
X113 WL49 NM113 MTJT
Vtest113 BL2 NM113 0
X114 WL50 NM114 MTJT
Vtest114 BL2 NM114 0
X115 WL51 NM115 MTJT
Vtest115 BL2 NM115 0
X116 WL52 NM116 MTJT
Vtest116 BL2 NM116 0
X117 WL53 NM117 MTJT
Vtest117 BL2 NM117 0
X118 WL54 NM118 MTJT
Vtest118 BL2 NM118 0
X119 WL55 NM119 MTJT
Vtest119 BL2 NM119 0
X120 WL56 NM120 MTJT
Vtest120 BL2 NM120 0
X121 WL57 NM121 MTJT
Vtest121 BL2 NM121 0
X122 WL58 NM122 MTJT
Vtest122 BL2 NM122 0
X123 WL59 NM123 MTJT
Vtest123 BL2 NM123 0
X124 WL60 NM124 MTJT
Vtest124 BL2 NM124 0
X125 WL61 NM125 MTJT
Vtest125 BL2 NM125 0
X126 WL62 NM126 MTJT
Vtest126 BL2 NM126 0
X127 WL63 NM127 MTJT
Vtest127 BL2 NM127 0
X128 WL64 NM128 MTJT
Vtest128 BL2 NM128 0
X129 WL1 NM129 MTJT
Vtest129 BL3 NM129 0
X130 WL2 NM130 MTJT
Vtest130 BL3 NM130 0
X131 WL3 NM131 MTJT
Vtest131 BL3 NM131 0
X132 WL4 NM132 MTJT
Vtest132 BL3 NM132 0
X133 WL5 NM133 MTJT
Vtest133 BL3 NM133 0
X134 WL6 NM134 MTJT
Vtest134 BL3 NM134 0
X135 WL7 NM135 MTJT
Vtest135 BL3 NM135 0
X136 WL8 NM136 MTJT
Vtest136 BL3 NM136 0
X137 WL9 NM137 MTJT
Vtest137 BL3 NM137 0
X138 WL10 NM138 MTJT
Vtest138 BL3 NM138 0
X139 WL11 NM139 MTJT
Vtest139 BL3 NM139 0
X140 WL12 NM140 MTJT
Vtest140 BL3 NM140 0
X141 WL13 NM141 MTJT
Vtest141 BL3 NM141 0
X142 WL14 NM142 MTJT
Vtest142 BL3 NM142 0
X143 WL15 NM143 MTJT
Vtest143 BL3 NM143 0
X144 WL16 NM144 MTJT
Vtest144 BL3 NM144 0
X145 WL17 NM145 MTJT
Vtest145 BL3 NM145 0
X146 WL18 NM146 MTJT
Vtest146 BL3 NM146 0
X147 WL19 NM147 MTJT
Vtest147 BL3 NM147 0
X148 WL20 NM148 MTJT
Vtest148 BL3 NM148 0
X149 WL21 NM149 MTJT
Vtest149 BL3 NM149 0
X150 WL22 NM150 MTJT
Vtest150 BL3 NM150 0
X151 WL23 NM151 MTJT
Vtest151 BL3 NM151 0
X152 WL24 NM152 MTJT
Vtest152 BL3 NM152 0
X153 WL25 NM153 MTJT
Vtest153 BL3 NM153 0
X154 WL26 NM154 MTJT
Vtest154 BL3 NM154 0
X155 WL27 NM155 MTJT
Vtest155 BL3 NM155 0
X156 WL28 NM156 MTJT
Vtest156 BL3 NM156 0
X157 WL29 NM157 MTJT
Vtest157 BL3 NM157 0
X158 WL30 NM158 MTJT
Vtest158 BL3 NM158 0
X159 WL31 NM159 MTJT
Vtest159 BL3 NM159 0
X160 WL32 NM160 MTJT
Vtest160 BL3 NM160 0
X161 WL33 NM161 MTJT
Vtest161 BL3 NM161 0
X162 WL34 NM162 MTJT
Vtest162 BL3 NM162 0
X163 WL35 NM163 MTJT
Vtest163 BL3 NM163 0
X164 WL36 NM164 MTJT
Vtest164 BL3 NM164 0
X165 WL37 NM165 MTJT
Vtest165 BL3 NM165 0
X166 WL38 NM166 MTJT
Vtest166 BL3 NM166 0
X167 WL39 NM167 MTJT
Vtest167 BL3 NM167 0
X168 WL40 NM168 MTJT
Vtest168 BL3 NM168 0
X169 WL41 NM169 MTJT
Vtest169 BL3 NM169 0
X170 WL42 NM170 MTJT
Vtest170 BL3 NM170 0
X171 WL43 NM171 MTJT
Vtest171 BL3 NM171 0
X172 WL44 NM172 MTJT
Vtest172 BL3 NM172 0
X173 WL45 NM173 MTJT
Vtest173 BL3 NM173 0
X174 WL46 NM174 MTJT
Vtest174 BL3 NM174 0
X175 WL47 NM175 MTJT
Vtest175 BL3 NM175 0
X176 WL48 NM176 MTJT
Vtest176 BL3 NM176 0
X177 WL49 NM177 MTJT
Vtest177 BL3 NM177 0
X178 WL50 NM178 MTJT
Vtest178 BL3 NM178 0
X179 WL51 NM179 MTJT
Vtest179 BL3 NM179 0
X180 WL52 NM180 MTJT
Vtest180 BL3 NM180 0
X181 WL53 NM181 MTJT
Vtest181 BL3 NM181 0
X182 WL54 NM182 MTJT
Vtest182 BL3 NM182 0
X183 WL55 NM183 MTJT
Vtest183 BL3 NM183 0
X184 WL56 NM184 MTJT
Vtest184 BL3 NM184 0
X185 WL57 NM185 MTJT
Vtest185 BL3 NM185 0
X186 WL58 NM186 MTJT
Vtest186 BL3 NM186 0
X187 WL59 NM187 MTJT
Vtest187 BL3 NM187 0
X188 WL60 NM188 MTJT
Vtest188 BL3 NM188 0
X189 WL61 NM189 MTJT
Vtest189 BL3 NM189 0
X190 WL62 NM190 MTJT
Vtest190 BL3 NM190 0
X191 WL63 NM191 MTJT
Vtest191 BL3 NM191 0
X192 WL64 NM192 MTJT
Vtest192 BL3 NM192 0
X193 WL1 NM193 MTJT
Vtest193 BL4 NM193 0
X194 WL2 NM194 MTJT
Vtest194 BL4 NM194 0
X195 WL3 NM195 MTJT
Vtest195 BL4 NM195 0
X196 WL4 NM196 MTJT
Vtest196 BL4 NM196 0
X197 WL5 NM197 MTJT
Vtest197 BL4 NM197 0
X198 WL6 NM198 MTJT
Vtest198 BL4 NM198 0
X199 WL7 NM199 MTJT
Vtest199 BL4 NM199 0
X200 WL8 NM200 MTJT
Vtest200 BL4 NM200 0
X201 WL9 NM201 MTJT
Vtest201 BL4 NM201 0
X202 WL10 NM202 MTJT
Vtest202 BL4 NM202 0
X203 WL11 NM203 MTJT
Vtest203 BL4 NM203 0
X204 WL12 NM204 MTJT
Vtest204 BL4 NM204 0
X205 WL13 NM205 MTJT
Vtest205 BL4 NM205 0
X206 WL14 NM206 MTJT
Vtest206 BL4 NM206 0
X207 WL15 NM207 MTJT
Vtest207 BL4 NM207 0
X208 WL16 NM208 MTJT
Vtest208 BL4 NM208 0
X209 WL17 NM209 MTJT
Vtest209 BL4 NM209 0
X210 WL18 NM210 MTJT
Vtest210 BL4 NM210 0
X211 WL19 NM211 MTJT
Vtest211 BL4 NM211 0
X212 WL20 NM212 MTJT
Vtest212 BL4 NM212 0
X213 WL21 NM213 MTJT
Vtest213 BL4 NM213 0
X214 WL22 NM214 MTJT
Vtest214 BL4 NM214 0
X215 WL23 NM215 MTJT
Vtest215 BL4 NM215 0
X216 WL24 NM216 MTJT
Vtest216 BL4 NM216 0
X217 WL25 NM217 MTJT
Vtest217 BL4 NM217 0
X218 WL26 NM218 MTJT
Vtest218 BL4 NM218 0
X219 WL27 NM219 MTJT
Vtest219 BL4 NM219 0
X220 WL28 NM220 MTJT
Vtest220 BL4 NM220 0
X221 WL29 NM221 MTJT
Vtest221 BL4 NM221 0
X222 WL30 NM222 MTJT
Vtest222 BL4 NM222 0
X223 WL31 NM223 MTJT
Vtest223 BL4 NM223 0
X224 WL32 NM224 MTJT
Vtest224 BL4 NM224 0
X225 WL33 NM225 MTJT
Vtest225 BL4 NM225 0
X226 WL34 NM226 MTJT
Vtest226 BL4 NM226 0
X227 WL35 NM227 MTJT
Vtest227 BL4 NM227 0
X228 WL36 NM228 MTJT
Vtest228 BL4 NM228 0
X229 WL37 NM229 MTJT
Vtest229 BL4 NM229 0
X230 WL38 NM230 MTJT
Vtest230 BL4 NM230 0
X231 WL39 NM231 MTJT
Vtest231 BL4 NM231 0
X232 WL40 NM232 MTJT
Vtest232 BL4 NM232 0
X233 WL41 NM233 MTJT
Vtest233 BL4 NM233 0
X234 WL42 NM234 MTJT
Vtest234 BL4 NM234 0
X235 WL43 NM235 MTJT
Vtest235 BL4 NM235 0
X236 WL44 NM236 MTJT
Vtest236 BL4 NM236 0
X237 WL45 NM237 MTJT
Vtest237 BL4 NM237 0
X238 WL46 NM238 MTJT
Vtest238 BL4 NM238 0
X239 WL47 NM239 MTJT
Vtest239 BL4 NM239 0
X240 WL48 NM240 MTJT
Vtest240 BL4 NM240 0
X241 WL49 NM241 MTJT
Vtest241 BL4 NM241 0
X242 WL50 NM242 MTJT
Vtest242 BL4 NM242 0
X243 WL51 NM243 MTJT
Vtest243 BL4 NM243 0
X244 WL52 NM244 MTJT
Vtest244 BL4 NM244 0
X245 WL53 NM245 MTJT
Vtest245 BL4 NM245 0
X246 WL54 NM246 MTJT
Vtest246 BL4 NM246 0
X247 WL55 NM247 MTJT
Vtest247 BL4 NM247 0
X248 WL56 NM248 MTJT
Vtest248 BL4 NM248 0
X249 WL57 NM249 MTJT
Vtest249 BL4 NM249 0
X250 WL58 NM250 MTJT
Vtest250 BL4 NM250 0
X251 WL59 NM251 MTJT
Vtest251 BL4 NM251 0
X252 WL60 NM252 MTJT
Vtest252 BL4 NM252 0
X253 WL61 NM253 MTJT
Vtest253 BL4 NM253 0
X254 WL62 NM254 MTJT
Vtest254 BL4 NM254 0
X255 WL63 NM255 MTJT
Vtest255 BL4 NM255 0
X256 WL64 NM256 MTJT
Vtest256 BL4 NM256 0
X257 WL1 NM257 MTJT
Vtest257 BL5 NM257 0
X258 WL2 NM258 MTJT
Vtest258 BL5 NM258 0
X259 WL3 NM259 MTJT
Vtest259 BL5 NM259 0
X260 WL4 NM260 MTJT
Vtest260 BL5 NM260 0
X261 WL5 NM261 MTJT
Vtest261 BL5 NM261 0
X262 WL6 NM262 MTJT
Vtest262 BL5 NM262 0
X263 WL7 NM263 MTJT
Vtest263 BL5 NM263 0
X264 WL8 NM264 MTJT
Vtest264 BL5 NM264 0
X265 WL9 NM265 MTJT
Vtest265 BL5 NM265 0
X266 WL10 NM266 MTJT
Vtest266 BL5 NM266 0
X267 WL11 NM267 MTJT
Vtest267 BL5 NM267 0
X268 WL12 NM268 MTJT
Vtest268 BL5 NM268 0
X269 WL13 NM269 MTJT
Vtest269 BL5 NM269 0
X270 WL14 NM270 MTJT
Vtest270 BL5 NM270 0
X271 WL15 NM271 MTJT
Vtest271 BL5 NM271 0
X272 WL16 NM272 MTJT
Vtest272 BL5 NM272 0
X273 WL17 NM273 MTJT
Vtest273 BL5 NM273 0
X274 WL18 NM274 MTJT
Vtest274 BL5 NM274 0
X275 WL19 NM275 MTJT
Vtest275 BL5 NM275 0
X276 WL20 NM276 MTJT
Vtest276 BL5 NM276 0
X277 WL21 NM277 MTJT
Vtest277 BL5 NM277 0
X278 WL22 NM278 MTJT
Vtest278 BL5 NM278 0
X279 WL23 NM279 MTJT
Vtest279 BL5 NM279 0
X280 WL24 NM280 MTJT
Vtest280 BL5 NM280 0
X281 WL25 NM281 MTJT
Vtest281 BL5 NM281 0
X282 WL26 NM282 MTJT
Vtest282 BL5 NM282 0
X283 WL27 NM283 MTJT
Vtest283 BL5 NM283 0
X284 WL28 NM284 MTJT
Vtest284 BL5 NM284 0
X285 WL29 NM285 MTJT
Vtest285 BL5 NM285 0
X286 WL30 NM286 MTJT
Vtest286 BL5 NM286 0
X287 WL31 NM287 MTJT
Vtest287 BL5 NM287 0
X288 WL32 NM288 MTJT
Vtest288 BL5 NM288 0
X289 WL33 NM289 MTJT
Vtest289 BL5 NM289 0
X290 WL34 NM290 MTJT
Vtest290 BL5 NM290 0
X291 WL35 NM291 MTJT
Vtest291 BL5 NM291 0
X292 WL36 NM292 MTJT
Vtest292 BL5 NM292 0
X293 WL37 NM293 MTJT
Vtest293 BL5 NM293 0
X294 WL38 NM294 MTJT
Vtest294 BL5 NM294 0
X295 WL39 NM295 MTJT
Vtest295 BL5 NM295 0
X296 WL40 NM296 MTJT
Vtest296 BL5 NM296 0
X297 WL41 NM297 MTJT
Vtest297 BL5 NM297 0
X298 WL42 NM298 MTJT
Vtest298 BL5 NM298 0
X299 WL43 NM299 MTJT
Vtest299 BL5 NM299 0
X300 WL44 NM300 MTJT
Vtest300 BL5 NM300 0
X301 WL45 NM301 MTJT
Vtest301 BL5 NM301 0
X302 WL46 NM302 MTJT
Vtest302 BL5 NM302 0
X303 WL47 NM303 MTJT
Vtest303 BL5 NM303 0
X304 WL48 NM304 MTJT
Vtest304 BL5 NM304 0
X305 WL49 NM305 MTJT
Vtest305 BL5 NM305 0
X306 WL50 NM306 MTJT
Vtest306 BL5 NM306 0
X307 WL51 NM307 MTJT
Vtest307 BL5 NM307 0
X308 WL52 NM308 MTJT
Vtest308 BL5 NM308 0
X309 WL53 NM309 MTJT
Vtest309 BL5 NM309 0
X310 WL54 NM310 MTJT
Vtest310 BL5 NM310 0
X311 WL55 NM311 MTJT
Vtest311 BL5 NM311 0
X312 WL56 NM312 MTJT
Vtest312 BL5 NM312 0
X313 WL57 NM313 MTJT
Vtest313 BL5 NM313 0
X314 WL58 NM314 MTJT
Vtest314 BL5 NM314 0
X315 WL59 NM315 MTJT
Vtest315 BL5 NM315 0
X316 WL60 NM316 MTJT
Vtest316 BL5 NM316 0
X317 WL61 NM317 MTJT
Vtest317 BL5 NM317 0
X318 WL62 NM318 MTJT
Vtest318 BL5 NM318 0
X319 WL63 NM319 MTJT
Vtest319 BL5 NM319 0
X320 WL64 NM320 MTJT
Vtest320 BL5 NM320 0
X321 WL1 NM321 MTJT
Vtest321 BL6 NM321 0
X322 WL2 NM322 MTJT
Vtest322 BL6 NM322 0
X323 WL3 NM323 MTJT
Vtest323 BL6 NM323 0
X324 WL4 NM324 MTJT
Vtest324 BL6 NM324 0
X325 WL5 NM325 MTJT
Vtest325 BL6 NM325 0
X326 WL6 NM326 MTJT
Vtest326 BL6 NM326 0
X327 WL7 NM327 MTJT
Vtest327 BL6 NM327 0
X328 WL8 NM328 MTJT
Vtest328 BL6 NM328 0
X329 WL9 NM329 MTJT
Vtest329 BL6 NM329 0
X330 WL10 NM330 MTJT
Vtest330 BL6 NM330 0
X331 WL11 NM331 MTJT
Vtest331 BL6 NM331 0
X332 WL12 NM332 MTJT
Vtest332 BL6 NM332 0
X333 WL13 NM333 MTJT
Vtest333 BL6 NM333 0
X334 WL14 NM334 MTJT
Vtest334 BL6 NM334 0
X335 WL15 NM335 MTJT
Vtest335 BL6 NM335 0
X336 WL16 NM336 MTJT
Vtest336 BL6 NM336 0
X337 WL17 NM337 MTJT
Vtest337 BL6 NM337 0
X338 WL18 NM338 MTJT
Vtest338 BL6 NM338 0
X339 WL19 NM339 MTJT
Vtest339 BL6 NM339 0
X340 WL20 NM340 MTJT
Vtest340 BL6 NM340 0
X341 WL21 NM341 MTJT
Vtest341 BL6 NM341 0
X342 WL22 NM342 MTJT
Vtest342 BL6 NM342 0
X343 WL23 NM343 MTJT
Vtest343 BL6 NM343 0
X344 WL24 NM344 MTJT
Vtest344 BL6 NM344 0
X345 WL25 NM345 MTJT
Vtest345 BL6 NM345 0
X346 WL26 NM346 MTJT
Vtest346 BL6 NM346 0
X347 WL27 NM347 MTJT
Vtest347 BL6 NM347 0
X348 WL28 NM348 MTJT
Vtest348 BL6 NM348 0
X349 WL29 NM349 MTJT
Vtest349 BL6 NM349 0
X350 WL30 NM350 MTJT
Vtest350 BL6 NM350 0
X351 WL31 NM351 MTJT
Vtest351 BL6 NM351 0
X352 WL32 NM352 MTJT
Vtest352 BL6 NM352 0
X353 WL33 NM353 MTJT
Vtest353 BL6 NM353 0
X354 WL34 NM354 MTJT
Vtest354 BL6 NM354 0
X355 WL35 NM355 MTJT
Vtest355 BL6 NM355 0
X356 WL36 NM356 MTJT
Vtest356 BL6 NM356 0
X357 WL37 NM357 MTJT
Vtest357 BL6 NM357 0
X358 WL38 NM358 MTJT
Vtest358 BL6 NM358 0
X359 WL39 NM359 MTJT
Vtest359 BL6 NM359 0
X360 WL40 NM360 MTJT
Vtest360 BL6 NM360 0
X361 WL41 NM361 MTJT
Vtest361 BL6 NM361 0
X362 WL42 NM362 MTJT
Vtest362 BL6 NM362 0
X363 WL43 NM363 MTJT
Vtest363 BL6 NM363 0
X364 WL44 NM364 MTJT
Vtest364 BL6 NM364 0
X365 WL45 NM365 MTJT
Vtest365 BL6 NM365 0
X366 WL46 NM366 MTJT
Vtest366 BL6 NM366 0
X367 WL47 NM367 MTJT
Vtest367 BL6 NM367 0
X368 WL48 NM368 MTJT
Vtest368 BL6 NM368 0
X369 WL49 NM369 MTJT
Vtest369 BL6 NM369 0
X370 WL50 NM370 MTJT
Vtest370 BL6 NM370 0
X371 WL51 NM371 MTJT
Vtest371 BL6 NM371 0
X372 WL52 NM372 MTJT
Vtest372 BL6 NM372 0
X373 WL53 NM373 MTJT
Vtest373 BL6 NM373 0
X374 WL54 NM374 MTJT
Vtest374 BL6 NM374 0
X375 WL55 NM375 MTJT
Vtest375 BL6 NM375 0
X376 WL56 NM376 MTJT
Vtest376 BL6 NM376 0
X377 WL57 NM377 MTJT
Vtest377 BL6 NM377 0
X378 WL58 NM378 MTJT
Vtest378 BL6 NM378 0
X379 WL59 NM379 MTJT
Vtest379 BL6 NM379 0
X380 WL60 NM380 MTJT
Vtest380 BL6 NM380 0
X381 WL61 NM381 MTJT
Vtest381 BL6 NM381 0
X382 WL62 NM382 MTJT
Vtest382 BL6 NM382 0
X383 WL63 NM383 MTJT
Vtest383 BL6 NM383 0
X384 WL64 NM384 MTJT
Vtest384 BL6 NM384 0
X385 WL1 NM385 MTJT
Vtest385 BL7 NM385 0
X386 WL2 NM386 MTJT
Vtest386 BL7 NM386 0
X387 WL3 NM387 MTJT
Vtest387 BL7 NM387 0
X388 WL4 NM388 MTJT
Vtest388 BL7 NM388 0
X389 WL5 NM389 MTJT
Vtest389 BL7 NM389 0
X390 WL6 NM390 MTJT
Vtest390 BL7 NM390 0
X391 WL7 NM391 MTJT
Vtest391 BL7 NM391 0
X392 WL8 NM392 MTJT
Vtest392 BL7 NM392 0
X393 WL9 NM393 MTJT
Vtest393 BL7 NM393 0
X394 WL10 NM394 MTJT
Vtest394 BL7 NM394 0
X395 WL11 NM395 MTJT
Vtest395 BL7 NM395 0
X396 WL12 NM396 MTJT
Vtest396 BL7 NM396 0
X397 WL13 NM397 MTJT
Vtest397 BL7 NM397 0
X398 WL14 NM398 MTJT
Vtest398 BL7 NM398 0
X399 WL15 NM399 MTJT
Vtest399 BL7 NM399 0
X400 WL16 NM400 MTJT
Vtest400 BL7 NM400 0
X401 WL17 NM401 MTJT
Vtest401 BL7 NM401 0
X402 WL18 NM402 MTJT
Vtest402 BL7 NM402 0
X403 WL19 NM403 MTJT
Vtest403 BL7 NM403 0
X404 WL20 NM404 MTJT
Vtest404 BL7 NM404 0
X405 WL21 NM405 MTJT
Vtest405 BL7 NM405 0
X406 WL22 NM406 MTJT
Vtest406 BL7 NM406 0
X407 WL23 NM407 MTJT
Vtest407 BL7 NM407 0
X408 WL24 NM408 MTJT
Vtest408 BL7 NM408 0
X409 WL25 NM409 MTJT
Vtest409 BL7 NM409 0
X410 WL26 NM410 MTJT
Vtest410 BL7 NM410 0
X411 WL27 NM411 MTJT
Vtest411 BL7 NM411 0
X412 WL28 NM412 MTJT
Vtest412 BL7 NM412 0
X413 WL29 NM413 MTJT
Vtest413 BL7 NM413 0
X414 WL30 NM414 MTJT
Vtest414 BL7 NM414 0
X415 WL31 NM415 MTJT
Vtest415 BL7 NM415 0
X416 WL32 NM416 MTJT
Vtest416 BL7 NM416 0
X417 WL33 NM417 MTJT
Vtest417 BL7 NM417 0
X418 WL34 NM418 MTJT
Vtest418 BL7 NM418 0
X419 WL35 NM419 MTJT
Vtest419 BL7 NM419 0
X420 WL36 NM420 MTJT
Vtest420 BL7 NM420 0
X421 WL37 NM421 MTJT
Vtest421 BL7 NM421 0
X422 WL38 NM422 MTJT
Vtest422 BL7 NM422 0
X423 WL39 NM423 MTJT
Vtest423 BL7 NM423 0
X424 WL40 NM424 MTJT
Vtest424 BL7 NM424 0
X425 WL41 NM425 MTJT
Vtest425 BL7 NM425 0
X426 WL42 NM426 MTJT
Vtest426 BL7 NM426 0
X427 WL43 NM427 MTJT
Vtest427 BL7 NM427 0
X428 WL44 NM428 MTJT
Vtest428 BL7 NM428 0
X429 WL45 NM429 MTJT
Vtest429 BL7 NM429 0
X430 WL46 NM430 MTJT
Vtest430 BL7 NM430 0
X431 WL47 NM431 MTJT
Vtest431 BL7 NM431 0
X432 WL48 NM432 MTJT
Vtest432 BL7 NM432 0
X433 WL49 NM433 MTJT
Vtest433 BL7 NM433 0
X434 WL50 NM434 MTJT
Vtest434 BL7 NM434 0
X435 WL51 NM435 MTJT
Vtest435 BL7 NM435 0
X436 WL52 NM436 MTJT
Vtest436 BL7 NM436 0
X437 WL53 NM437 MTJT
Vtest437 BL7 NM437 0
X438 WL54 NM438 MTJT
Vtest438 BL7 NM438 0
X439 WL55 NM439 MTJT
Vtest439 BL7 NM439 0
X440 WL56 NM440 MTJT
Vtest440 BL7 NM440 0
X441 WL57 NM441 MTJT
Vtest441 BL7 NM441 0
X442 WL58 NM442 MTJT
Vtest442 BL7 NM442 0
X443 WL59 NM443 MTJT
Vtest443 BL7 NM443 0
X444 WL60 NM444 MTJT
Vtest444 BL7 NM444 0
X445 WL61 NM445 MTJT
Vtest445 BL7 NM445 0
X446 WL62 NM446 MTJT
Vtest446 BL7 NM446 0
X447 WL63 NM447 MTJT
Vtest447 BL7 NM447 0
X448 WL64 NM448 MTJT
Vtest448 BL7 NM448 0
X449 WL1 NM449 MTJT
Vtest449 BL8 NM449 0
X450 WL2 NM450 MTJT
Vtest450 BL8 NM450 0
X451 WL3 NM451 MTJT
Vtest451 BL8 NM451 0
X452 WL4 NM452 MTJT
Vtest452 BL8 NM452 0
X453 WL5 NM453 MTJT
Vtest453 BL8 NM453 0
X454 WL6 NM454 MTJT
Vtest454 BL8 NM454 0
X455 WL7 NM455 MTJT
Vtest455 BL8 NM455 0
X456 WL8 NM456 MTJT
Vtest456 BL8 NM456 0
X457 WL9 NM457 MTJT
Vtest457 BL8 NM457 0
X458 WL10 NM458 MTJT
Vtest458 BL8 NM458 0
X459 WL11 NM459 MTJT
Vtest459 BL8 NM459 0
X460 WL12 NM460 MTJT
Vtest460 BL8 NM460 0
X461 WL13 NM461 MTJT
Vtest461 BL8 NM461 0
X462 WL14 NM462 MTJT
Vtest462 BL8 NM462 0
X463 WL15 NM463 MTJT
Vtest463 BL8 NM463 0
X464 WL16 NM464 MTJT
Vtest464 BL8 NM464 0
X465 WL17 NM465 MTJT
Vtest465 BL8 NM465 0
X466 WL18 NM466 MTJT
Vtest466 BL8 NM466 0
X467 WL19 NM467 MTJT
Vtest467 BL8 NM467 0
X468 WL20 NM468 MTJT
Vtest468 BL8 NM468 0
X469 WL21 NM469 MTJT
Vtest469 BL8 NM469 0
X470 WL22 NM470 MTJT
Vtest470 BL8 NM470 0
X471 WL23 NM471 MTJT
Vtest471 BL8 NM471 0
X472 WL24 NM472 MTJT
Vtest472 BL8 NM472 0
X473 WL25 NM473 MTJT
Vtest473 BL8 NM473 0
X474 WL26 NM474 MTJT
Vtest474 BL8 NM474 0
X475 WL27 NM475 MTJT
Vtest475 BL8 NM475 0
X476 WL28 NM476 MTJT
Vtest476 BL8 NM476 0
X477 WL29 NM477 MTJT
Vtest477 BL8 NM477 0
X478 WL30 NM478 MTJT
Vtest478 BL8 NM478 0
X479 WL31 NM479 MTJT
Vtest479 BL8 NM479 0
X480 WL32 NM480 MTJT
Vtest480 BL8 NM480 0
X481 WL33 NM481 MTJT
Vtest481 BL8 NM481 0
X482 WL34 NM482 MTJT
Vtest482 BL8 NM482 0
X483 WL35 NM483 MTJT
Vtest483 BL8 NM483 0
X484 WL36 NM484 MTJT
Vtest484 BL8 NM484 0
X485 WL37 NM485 MTJT
Vtest485 BL8 NM485 0
X486 WL38 NM486 MTJT
Vtest486 BL8 NM486 0
X487 WL39 NM487 MTJT
Vtest487 BL8 NM487 0
X488 WL40 NM488 MTJT
Vtest488 BL8 NM488 0
X489 WL41 NM489 MTJT
Vtest489 BL8 NM489 0
X490 WL42 NM490 MTJT
Vtest490 BL8 NM490 0
X491 WL43 NM491 MTJT
Vtest491 BL8 NM491 0
X492 WL44 NM492 MTJT
Vtest492 BL8 NM492 0
X493 WL45 NM493 MTJT
Vtest493 BL8 NM493 0
X494 WL46 NM494 MTJT
Vtest494 BL8 NM494 0
X495 WL47 NM495 MTJT
Vtest495 BL8 NM495 0
X496 WL48 NM496 MTJT
Vtest496 BL8 NM496 0
X497 WL49 NM497 MTJT
Vtest497 BL8 NM497 0
X498 WL50 NM498 MTJT
Vtest498 BL8 NM498 0
X499 WL51 NM499 MTJT
Vtest499 BL8 NM499 0
X500 WL52 NM500 MTJT
Vtest500 BL8 NM500 0
X501 WL53 NM501 MTJT
Vtest501 BL8 NM501 0
X502 WL54 NM502 MTJT
Vtest502 BL8 NM502 0
X503 WL55 NM503 MTJT
Vtest503 BL8 NM503 0
X504 WL56 NM504 MTJT
Vtest504 BL8 NM504 0
X505 WL57 NM505 MTJT
Vtest505 BL8 NM505 0
X506 WL58 NM506 MTJT
Vtest506 BL8 NM506 0
X507 WL59 NM507 MTJT
Vtest507 BL8 NM507 0
X508 WL60 NM508 MTJT
Vtest508 BL8 NM508 0
X509 WL61 NM509 MTJT
Vtest509 BL8 NM509 0
X510 WL62 NM510 MTJT
Vtest510 BL8 NM510 0
X511 WL63 NM511 MTJT
Vtest511 BL8 NM511 0
X512 WL64 NM512 MTJT
Vtest512 BL8 NM512 0

X514 WL1T WL1 ENWl Vdd Gnd TG
X515 WL2T WL2 ENWl Vdd Gnd TG
X516 WL3T WL3 ENWl Vdd Gnd TG
X517 WL4T WL4 ENWl Vdd Gnd TG
X518 WL5T WL5 ENWl Vdd Gnd TG
X519 WL6T WL6 ENWl Vdd Gnd TG
X520 WL7T WL7 ENWl Vdd Gnd TG
X521 WL8T WL8 ENWl Vdd Gnd TG
X522 WL9T WL9 ENWl Vdd Gnd TG
X523 WL10T WL10 ENWl Vdd Gnd TG
X524 WL11T WL11 ENWl Vdd Gnd TG
X525 WL12T WL12 ENWl Vdd Gnd TG
X526 WL13T WL13 ENWl Vdd Gnd TG
X527 WL14T WL14 ENWl Vdd Gnd TG
X528 WL15T WL15 ENWl Vdd Gnd TG
X529 WL16T WL16 ENWl Vdd Gnd TG
X530 WL17T WL17 ENWl Vdd Gnd TG
X531 WL18T WL18 ENWl Vdd Gnd TG
X532 WL19T WL19 ENWl Vdd Gnd TG
X533 WL20T WL20 ENWl Vdd Gnd TG
X534 WL21T WL21 ENWl Vdd Gnd TG
X535 WL22T WL22 ENWl Vdd Gnd TG
X536 WL23T WL23 ENWl Vdd Gnd TG
X537 WL24T WL24 ENWl Vdd Gnd TG
X538 WL25T WL25 ENWl Vdd Gnd TG
X539 WL26T WL26 ENWl Vdd Gnd TG
X540 WL27T WL27 ENWl Vdd Gnd TG
X541 WL28T WL28 ENWl Vdd Gnd TG
X542 WL29T WL29 ENWl Vdd Gnd TG
X543 WL30T WL30 ENWl Vdd Gnd TG
X544 WL31T WL31 ENWl Vdd Gnd TG
X545 WL32T WL32 ENWl1 Vdd Gnd TG
X546 WL33T WL33 ENWl Vdd Gnd TG
X547 WL34T WL34 ENWl Vdd Gnd TG
X548 WL35T WL35 ENWl Vdd Gnd TG
X549 WL36T WL36 ENWl Vdd Gnd TG
X550 WL37T WL37 ENWl Vdd Gnd TG
X551 WL38T WL38 ENWl Vdd Gnd TG
X552 WL39T WL39 ENWl Vdd Gnd TG
X553 WL40T WL40 ENWl Vdd Gnd TG
X554 WL41T WL41 ENWl Vdd Gnd TG
X555 WL42T WL42 ENWl Vdd Gnd TG
X556 WL43T WL43 ENWl Vdd Gnd TG
X557 WL44T WL44 ENWl Vdd Gnd TG
X558 WL45T WL45 ENWl Vdd Gnd TG
X559 WL46T WL46 ENWl Vdd Gnd TG
X560 WL47T WL47 ENWl Vdd Gnd TG
X561 WL48T WL48 ENWl Vdd Gnd TG
X562 WL49T WL49 ENWl Vdd Gnd TG
X563 WL50T WL50 ENWl Vdd Gnd TG
X564 WL51T WL51 ENWl Vdd Gnd TG
X565 WL52T WL52 ENWl Vdd Gnd TG
X566 WL53T WL53 ENWl Vdd Gnd TG
X567 WL54T WL54 ENWl Vdd Gnd TG
X568 WL55T WL55 ENWl Vdd Gnd TG
X569 WL56T WL56 ENWl Vdd Gnd TG
X570 WL57T WL57 ENWl Vdd Gnd TG
X571 WL58T WL58 ENWl Vdd Gnd TG
X572 WL59T WL59 ENWl Vdd Gnd TG
X573 WL60T WL60 ENWl Vdd Gnd TG
X574 WL61T WL61 ENWl Vdd Gnd TG
X575 WL62T WL62 ENWl Vdd Gnd TG
X576 WL63T WL63 ENWl Vdd Gnd TG
X577 WL64T WL64 ENWl Vdd Gnd TG

X599 BL1T BL1 ENBl1 Vdd Gnd TG
X590 BL2T BL2 ENBl2 Vdd Gnd TG
X591 BL3T BL3 ENBl3 Vdd Gnd TG
X592 BL4T BL4 ENBl4 Vdd Gnd TG
X593 BL5T BL5 ENBl5 Vdd Gnd TG
X594 BL6T BL6 ENBl6 Vdd Gnd TG
X595 BL7T BL7 ENBl7 Vdd Gnd TG
X596 BL8T BL8 ENBl8 Vdd Gnd TG

* Bitlines Capacitance

Cbl1 BL1 Gnd 'cap'
Cbl2 BL2 Gnd 'cap'
Cbl3 BL3 Gnd 'cap'
Cbl4 BL4 Gnd 'cap'
Cbl5 BL5 Gnd 'cap'
Cbl6 BL6 Gnd 'cap'
Cbl7 BL7 Gnd 'cap'
Cbl8 BL8 Gnd 'cap'

R1 BL1 Gnd 'res'
R2 BL2 Gnd 'res'
R3 BL3 Gnd 'res'
R4 BL4 Gnd 'res'
R5 BL5 Gnd 'res'
R6 BL6 Gnd 'res'
R7 BL7 Gnd 'res'
R8 BL8 Gnd 'res'

Cbl11 WL1 Gnd 'cap'
Cbl12 WL2 Gnd 'cap'
Cbl13 WL3 Gnd 'cap'
Cbl14 WL4 Gnd 'cap'
Cbl15 WL5 Gnd 'cap'
Cbl16 WL6 Gnd 'cap'
Cbl17 WL7 Gnd 'cap'
Cbl18 WL8 Gnd 'cap'
Cbl19 WL9 Gnd 'cap'
Cbl20 WL10 Gnd 'cap'
Cbl21 WL11 Gnd 'cap'
Cbl22 WL12 Gnd 'cap'
Cbl23 WL13 Gnd 'cap'
Cbl24 WL14 Gnd 'cap'
Cbl25 WL15 Gnd 'cap'
Cbl26 WL16 Gnd 'cap'
Cbl27 WL17 Gnd 'cap'
Cbl28 WL18 Gnd 'cap'
Cbl29 WL19 Gnd 'cap'
Cbl30 WL20 Gnd 'cap'
Cbl31 WL21 Gnd 'cap'
Cbl32 WL22 Gnd 'cap'
Cbl33 WL23 Gnd 'cap'
Cbl34 WL24 Gnd 'cap'
Cbl35 WL25 Gnd 'cap'
Cbl36 WL26 Gnd 'cap'
Cbl37 WL27 Gnd 'cap'
Cbl38 WL28 Gnd 'cap'
Cbl39 WL29 Gnd 'cap'
Cbl40 WL30 Gnd 'cap'
Cbl41 WL31 Gnd 'cap'
Cbl42 WL32 Gnd 'cap'
Cbl43 WL33 Gnd 'cap'
Cbl44 WL34 Gnd 'cap'
Cbl45 WL35 Gnd 'cap'
Cbl46 WL36 Gnd 'cap'
Cbl47 WL37 Gnd 'cap'
Cbl48 WL38 Gnd 'cap'
Cbl49 WL39 Gnd 'cap'
Cbl50 WL40 Gnd 'cap'
Cbl51 WL41 Gnd 'cap'
Cbl52 WL42 Gnd 'cap'
Cbl53 WL43 Gnd 'cap'
Cbl54 WL44 Gnd 'cap'
Cbl55 WL45 Gnd 'cap'
Cbl56 WL46 Gnd 'cap'
Cbl57 WL47 Gnd 'cap'
Cbl58 WL48 Gnd 'cap'
Cbl59 WL49 Gnd 'cap'
Cbl60 WL50 Gnd 'cap'
Cbl61 WL51 Gnd 'cap'
Cbl62 WL52 Gnd 'cap'
Cbl63 WL53 Gnd 'cap'
Cbl64 WL54 Gnd 'cap'
Cbl65 WL55 Gnd 'cap'
Cbl66 WL56 Gnd 'cap'
Cbl67 WL57 Gnd 'cap'
Cbl68 WL58 Gnd 'cap'
Cbl69 WL59 Gnd 'cap'
Cbl70 WL60 Gnd 'cap'
Cbl71 WL61 Gnd 'cap'
Cbl72 WL62 Gnd 'cap'
Cbl73 WL63 Gnd 'cap'
Cbl74 WL64 Gnd 'cap'

.TRAN 1p 10n

.option rawfmt="psfbin" cmin=5f
