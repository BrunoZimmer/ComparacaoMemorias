* Crossbar one bit

simulator lang=spice

.include '45nm_LP.pm'
.include 'MTJT.spi'
.include 'TRANSGATE.spi'

.param cap = 1.5f

.param Vvdd = 1.6

.param Vgnd = 0

.param Vread = 1

.param TpWrite = 0.7n
.param TpRead = 0.3n
.param TpPulse = 0.9n

Vwl1 WL1T Gnd PWL 0 'Vgnd'
Vwl2 WL2T Gnd PWL 0 'Vgnd'
Vwl3 WL3T Gnd PWL 0 'Vgnd'
Vwl4 WL4T Gnd PWL 0 'Vgnd' 'TpPulse-1p' 'Vgnd' 'TpPulse' 'Vvdd' '5n' 'Vvdd' '5n+1p' 'Vgnd' '8n+TpRead' 'Vgnd' '8n+TpRead+1p' 'Vread' '9n-1p' 'Vread' '9n' 'Vgnd'
Vwl5 WL5T Gnd PWL 0 'Vgnd'
Vwl6 WL6T Gnd PWL 0 'Vgnd'
Vwl7 WL7T Gnd PWL 0 'Vgnd'
Vwl8 WL8T Gnd PWL 0 'Vgnd'

Vbl1 BL1T Gnd PWL 0 'Vgnd'
Vbl2 BL2T Gnd PWL 0 'Vgnd'
Vbl3 BL3T Gnd PWL 0 'Vgnd'
Vbl4 BL4T Gnd PWL 0 'Vgnd'
Vbl5 BL5T Gnd PWL 0 'Vgnd'
Vbl6 BL6T Gnd PWL 0 'Vgnd'
Vbl7 BL7T Gnd PWL 0 'Vgnd'
Vbl8 BL8T Gnd PWL 0 'Vgnd' '5n+TpWrite-1p' 'Vgnd' '5n+TpWrite' 'Vvdd' '7n-1p' 'Vvdd' '7n' 'Vgnd'
Vbl9 BL9T Gnd PWL 0 'Vgnd'
Vbl10 BL10T Gnd PWL 0 'Vgnd'
Vbl11 BL11T Gnd PWL 0 'Vgnd'
Vbl12 BL12T Gnd PWL 0 'Vgnd'
Vbl13 BL13T Gnd PWL 0 'Vgnd'
Vbl14 BL14T Gnd PWL 0 'Vgnd'
Vbl15 BL15T Gnd PWL 0 'Vgnd'
Vbl16 BL16T Gnd PWL 0 'Vgnd'

Vwl1en ENWl1 Gnd PWL 0 'Vgnd'
Vwl2en ENWl2 Gnd PWL 0 'Vgnd'
Vwl3en ENWl3 Gnd PWL 0 'Vgnd'
Vwl4en ENWl4 Gnd PWL 0 'Vgnd' 'TpPulse-1p' 'Vgnd' 'TpPulse' 'Vvdd' '5n' 'Vvdd' '5n+1p' 'Vgnd' '5n+TpWrite-1p' 'Vgnd' '5n+TpWrite' 'Vvdd' '7n-1p' 'Vvdd' '7n' 'Vgnd' '8n+TpRead-1p' 'Vgnd' '8n+TpRead' 'Vvdd' '9n-1p' 'Vvdd' '9n' 'Vgnd'
Vwl5en ENWl5 Gnd PWL 0 'Vgnd'
Vwl6en ENWl6 Gnd PWL 0 'Vgnd'
Vwl7en ENWl7 Gnd PWL 0 'Vgnd'
Vwl8en ENWl8 Gnd PWL 0 'Vgnd'

Vbl1en ENBl1 Gnd PWL 0 'Vgnd'
Vbl2en ENBl2 Gnd PWL 0 'Vgnd'
Vbl3en ENBl3 Gnd PWL 0 'Vgnd'
Vbl4en ENBl4 Gnd PWL 0 'Vgnd'
Vbl5en ENBl5 Gnd PWL 0 'Vgnd'
Vbl6en ENBl6 Gnd PWL 0 'Vgnd'
Vbl7en ENBl7 Gnd PWL 0 'Vgnd'
Vbl8en ENBl8 Gnd PWL 0 'Vgnd' 'TpPulse-1p' 'Vgnd' 'TpPulse' 'Vvdd' '5n' 'Vvdd' '5n+1p' 'Vgnd' '5n+TpWrite-1p' 'Vgnd' '5n+TpWrite' 'Vvdd' '7n-1p' 'Vvdd' '7n' 'Vgnd' '8n+TpRead-1p' 'Vgnd' '8n+TpRead' 'Vvdd' '9n-1p' 'Vvdd' '9n' 'Vgnd'
Vbl9en ENBl9 Gnd PWL 0 'Vgnd'
Vbl10en ENBl10 Gnd PWL 0 'Vgnd'
Vbl11en ENBl11 Gnd PWL 0 'Vgnd'
Vbl12en ENBl12 Gnd PWL 0 'Vgnd'
Vbl13en ENBl13 Gnd PWL 0 'Vgnd'
Vbl14en ENBl14 Gnd PWL 0 'Vgnd'
Vbl15en ENBl15 Gnd PWL 0 'Vgnd'
Vbl16en ENBl16 Gnd PWL 0 'Vgnd'

Vvdd Vdd Gnd 'Vvdd'

* Bitcell

X1 WL1 NM1 MTJT
Vtest1 BL1 NM1 0

X2 WL1 NM2 MTJT
Vtest2 BL2 NM2 0

X3 WL1 NM3 MTJT
Vtest3 BL3 NM3 0

X4 WL1 NM4 MTJT
Vtest4 BL4 NM4 0

X5 WL1 NM5 MTJT
Vtest5 BL5 NM5 0

X6 WL1 NM6 MTJT
Vtest6 BL6 NM6 0

X7 WL1 NM7 MTJT
Vtest7 BL7 NM7 0

X8 WL1 NM8 MTJT
Vtest8 BL8 NM8 0

X9 WL1 NM9 MTJT
Vtest9 BL9 NM9 0

X10 WL1 NM10 MTJT
Vtest10 BL10 NM10 0

X11 WL1 NM11 MTJT
Vtest11 BL11 NM11 0

X12 WL1 NM12 MTJT
Vtest12 BL12 NM12 0

X13 WL1 NM13 MTJT
Vtest13 BL13 NM13 0

X14 WL1 NM14 MTJT
Vtest14 BL14 NM14 0

X15 WL1 NM15 MTJT
Vtest15 BL15 NM15 0

X16 WL1 NM16 MTJT
Vtest16 BL16 NM16 0

X17 WL2 NM17 MTJT
Vtest17 BL1 NM17 0

X18 WL2 NM18 MTJT
Vtest18 BL2 NM18 0

X19 WL2 NM19 MTJT
Vtest19 BL3 NM19 0

X20 WL2 NM20 MTJT
Vtest20 BL4 NM20 0

X21 WL2 NM21 MTJT
Vtest21 BL5 NM21 0

X22 WL2 NM22 MTJT
Vtest22 BL6 NM22 0

X23 WL2 NM23 MTJT
Vtest23 BL7 NM23 0

X24 WL2 NM24 MTJT
Vtest24 BL8 NM24 0

X25 WL2 NM25 MTJT
Vtest25 BL9 NM25 0

X26 WL2 NM26 MTJT
Vtest26 BL10 NM26 0

X27 WL2 NM27 MTJT
Vtest27 BL11 NM27 0

X28 WL2 NM28 MTJT
Vtest28 BL12 NM28 0

X29 WL2 NM29 MTJT
Vtest29 BL13 NM29 0

X30 WL2 NM30 MTJT
Vtest30 BL14 NM30 0

X31 WL2 NM31 MTJT
Vtest31 BL15 NM31 0

X32 WL2 NM32 MTJT
Vtest32 BL16 NM32 0

X33 WL3 NM33 MTJT
Vtest33 BL1 NM33 0

X34 WL3 NM34 MTJT
Vtest34 BL2 NM34 0

X35 WL3 NM35 MTJT
Vtest35 BL3 NM35 0

X36 WL3 NM36 MTJT
Vtest36 BL4 NM36 0

X37 WL3 NM37 MTJT
Vtest37 BL5 NM37 0

X38 WL3 NM38 MTJT
Vtest38 BL6 NM38 0

X39 WL3 NM39 MTJT
Vtest39 BL7 NM39 0

X40 WL3 NM40 MTJT
Vtest40 BL8 NM40 0

X41 WL3 NM41 MTJT
Vtest41 BL9 NM41 0

X42 WL3 NM42 MTJT
Vtest42 BL10 NM42 0

X43 WL3 NM43 MTJT
Vtest43 BL11 NM43 0

X44 WL3 NM44 MTJT
Vtest44 BL12 NM44 0

X45 WL3 NM45 MTJT
Vtest45 BL13 NM45 0

X46 WL3 NM46 MTJT
Vtest46 BL14 NM46 0

X47 WL3 NM47 MTJT
Vtest47 BL15 NM47 0

X48 WL3 NM48 MTJT
Vtest48 BL16 NM48 0

X49 WL4 NM49 MTJT
Vtest49 BL1 NM49 0

X50 WL4 NM50 MTJT
Vtest50 BL2 NM50 0

X51 WL4 NM51 MTJT
Vtest51 BL3 NM51 0

X52 WL4 NM52 MTJT
Vtest52 BL4 NM52 0

X53 WL4 NM53 MTJT
Vtest53 BL5 NM53 0

X54 WL4 NM54 MTJT
Vtest54 BL6 NM54 0

X55 WL4 NM55 MTJT
Vtest55 BL7 NM55 0

X56 WL4 NM56 MTJT
Vtest56 BL8 NM56 0

X57 WL4 NM57 MTJT
Vtest57 BL9 NM57 0

X58 WL4 NM58 MTJT
Vtest58 BL10 NM58 0

X59 WL4 NM59 MTJT
Vtest59 BL11 NM59 0

X60 WL4 NM60 MTJT
Vtest60 BL12 NM60 0

X61 WL4 NM61 MTJT
Vtest61 BL13 NM61 0

X62 WL4 NM62 MTJT
Vtest62 BL14 NM62 0

X63 WL4 NM63 MTJT
Vtest63 BL15 NM63 0

X64 WL4 NM64 MTJT
Vtest64 BL16 NM64 0

X65 WL5 NM65 MTJT
Vtest65 BL1 NM65 0

X66 WL5 NM66 MTJT
Vtest66 BL2 NM66 0

X67 WL5 NM67 MTJT
Vtest67 BL3 NM67 0

X68 WL5 NM68 MTJT
Vtest68 BL4 NM68 0

X69 WL5 NM69 MTJT
Vtest69 BL5 NM69 0

X70 WL5 NM70 MTJT
Vtest70 BL6 NM70 0

X71 WL5 NM71 MTJT
Vtest71 BL7 NM71 0

X72 WL5 NM72 MTJT
Vtest72 BL8 NM72 0

X73 WL5 NM73 MTJT
Vtest73 BL9 NM73 0

X74 WL5 NM74 MTJT
Vtest74 BL10 NM74 0

X75 WL5 NM75 MTJT
Vtest75 BL11 NM75 0

X76 WL5 NM76 MTJT
Vtest76 BL12 NM76 0

X77 WL5 NM77 MTJT
Vtest77 BL13 NM77 0

X78 WL5 NM78 MTJT
Vtest78 BL14 NM78 0

X79 WL5 NM79 MTJT
Vtest79 BL15 NM79 0

X80 WL5 NM80 MTJT
Vtest80 BL16 NM80 0

X81 WL6 NM81 MTJT
Vtest81 BL1 NM81 0

X82 WL6 NM82 MTJT
Vtest82 BL2 NM82 0

X83 WL6 NM83 MTJT
Vtest83 BL3 NM83 0

X84 WL6 NM84 MTJT
Vtest84 BL4 NM84 0

X85 WL6 NM85 MTJT
Vtest85 BL5 NM85 0

X86 WL6 NM86 MTJT
Vtest86 BL6 NM86 0

X87 WL6 NM87 MTJT
Vtest87 BL7 NM87 0

X88 WL6 NM88 MTJT
Vtest88 BL8 NM88 0

X89 WL6 NM89 MTJT
Vtest89 BL9 NM89 0

X90 WL6 NM90 MTJT
Vtest90 BL10 NM90 0

X91 WL6 NM91 MTJT
Vtest91 BL11 NM91 0

X92 WL6 NM92 MTJT
Vtest92 BL12 NM92 0

X93 WL6 NM93 MTJT
Vtest93 BL13 NM93 0

X94 WL6 NM94 MTJT
Vtest94 BL14 NM94 0

X95 WL6 NM95 MTJT
Vtest95 BL15 NM95 0

X96 WL6 NM96 MTJT
Vtest96 BL16 NM96 0

X97 WL7 NM97 MTJT
Vtest97 BL1 NM97 0

X98 WL7 NM98 MTJT
Vtest98 BL2 NM98 0

X99 WL7 NM99 MTJT
Vtest99 BL3 NM99 0

X100 WL7 NM100 MTJT
Vtest100 BL4 NM100 0

X101 WL7 NM101 MTJT
Vtest101 BL5 NM101 0

X102 WL7 NM102 MTJT
Vtest102 BL6 NM102 0

X103 WL7 NM103 MTJT
Vtest103 BL7 NM103 0

X104 WL7 NM104 MTJT
Vtest104 BL8 NM104 0

X105 WL7 NM105 MTJT
Vtest105 BL9 NM105 0

X106 WL7 NM106 MTJT
Vtest106 BL10 NM106 0

X107 WL7 NM107 MTJT
Vtest107 BL11 NM107 0

X108 WL7 NM108 MTJT
Vtest108 BL12 NM108 0

X109 WL7 NM109 MTJT
Vtest109 BL13 NM109 0

X110 WL7 NM110 MTJT
Vtest110 BL14 NM110 0

X111 WL7 NM111 MTJT
Vtest111 BL15 NM111 0

X112 WL7 NM112 MTJT
Vtest112 BL16 NM112 0

X113 WL8 NM113 MTJT
Vtest113 BL1 NM113 0

X114 WL8 NM114 MTJT
Vtest114 BL2 NM114 0

X115 WL8 NM115 MTJT
Vtest115 BL3 NM115 0

X116 WL8 NM116 MTJT
Vtest116 BL4 NM116 0

X117 WL8 NM117 MTJT
Vtest117 BL5 NM117 0

X118 WL8 NM118 MTJT
Vtest118 BL6 NM118 0

X119 WL8 NM119 MTJT
Vtest119 BL7 NM119 0

X120 WL8 NM120 MTJT
Vtest120 BL8 NM120 0

X121 WL8 NM121 MTJT
Vtest121 BL9 NM121 0

X122 WL8 NM122 MTJT
Vtest122 BL10 NM122 0

X123 WL8 NM123 MTJT
Vtest123 BL11 NM123 0

X124 WL8 NM124 MTJT
Vtest124 BL12 NM124 0

X125 WL8 NM125 MTJT
Vtest125 BL13 NM125 0

X126 WL8 NM126 MTJT
Vtest126 BL14 NM126 0

X127 WL8 NM127 MTJT
Vtest127 BL15 NM127 0

X128 WL8 NM128 MTJT
Vtest128 BL16 NM128 0

* Tristate

X130 WL1T WL1 ENWl1 Vdd Gnd TG
X131 WL2T WL2 ENWl2 Vdd Gnd TG
X132 WL3T WL3 ENWl3 Vdd Gnd TG
X133 WL4T WL4 ENWl4 Vdd Gnd TG
X134 WL5T WL5 ENWl5 Vdd Gnd TG
X135 WL6T WL6 ENWl6 Vdd Gnd TG
X136 WL7T WL7 ENWl7 Vdd Gnd TG
X137 WL8T WL8 ENWl8 Vdd Gnd TG
X139 BL1T BL1 ENBl1 Vdd Gnd TG
X140 BL2T BL2 ENBl2 Vdd Gnd TG
X141 BL3T BL3 ENBl3 Vdd Gnd TG
X142 BL4T BL4 ENBl4 Vdd Gnd TG
X143 BL5T BL5 ENBl5 Vdd Gnd TG
X144 BL6T BL6 ENBl6 Vdd Gnd TG
X145 BL7T BL7 ENBl7 Vdd Gnd TG
X146 BL8T BL8 ENBl8 Vdd Gnd TG
X147 BL9T BL9 ENBl9 Vdd Gnd TG
X148 BL10T BL10 ENBl10 Vdd Gnd TG
X149 BL11T BL11 ENBl11 Vdd Gnd TG
X150 BL12T BL12 ENBl12 Vdd Gnd TG
X151 BL13T BL13 ENBl13 Vdd Gnd TG
X152 BL14T BL14 ENBl14 Vdd Gnd TG
X153 BL15T BL15 ENBl15 Vdd Gnd TG
X154 BL16T BL16 ENBl16 Vdd Gnd TG

* Bitlines Capacitance

Cbl162 BL1 Gnd 'cap'
Cbl163 BL2 Gnd 'cap'
Cbl164 BL3 Gnd 'cap'
Cbl165 BL4 Gnd 'cap'
Cbl166 BL5 Gnd 'cap'
Cbl167 BL6 Gnd 'cap'
Cbl168 BL7 Gnd 'cap'
Cbl169 BL8 Gnd 'cap'
Cbl170 BL9 Gnd 'cap'
Cbl171 BL10 Gnd 'cap'
Cbl172 BL11 Gnd 'cap'
Cbl173 BL12 Gnd 'cap'
Cbl174 BL13 Gnd 'cap'
Cbl175 BL14 Gnd 'cap'
Cbl176 BL15 Gnd 'cap'
Cbl177 BL16 Gnd 'cap'

.TRAN 1p 10n

.option rawfmt="psfbin"
