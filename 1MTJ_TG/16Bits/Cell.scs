* Crossbar one bit

simulator lang=spice

.include '45nm_LP.pm'
.include 'MTJT.spi'
.include 'TRANSGATE.spi'

.param cap = 1.5f

.param Vvdd = 1.6

.param Vgnd = 0

.param Vread = 1

.param TpWrite = 0.7n
.param TpRead = 0.3n
.param TpPulse = 0.9n

Vwl1 WL1T Gnd PWL 0 'Vgnd'
Vwl2 WL2T Gnd PWL 0 'Vgnd' 'TpPulse-1p' 'Vgnd' 'TpPulse' 'Vvdd' '5n' 'Vvdd' '5n+1p' 'Vgnd' '8n+TpRead' 'Vgnd' '8n+TpRead+1p' 'Vread' '9n-1p' 'Vread' '9n' 'Vgnd'
Vwl3 WL3T Gnd PWL 0 'Vgnd'
Vwl4 WL4T Gnd PWL 0 'Vgnd'

Vbl1 BL1T Gnd PWL 0 'Vgnd'
Vbl2 BL2T Gnd PWL 0 'Vgnd' '5n+TpWrite-1p' 'Vgnd' '5n+TpWrite' 'Vvdd' '7n-1p' 'Vvdd' '7n' 'Vgnd'
Vbl3 BL3T Gnd PWL 0 'Vgnd'
Vbl4 BL4T Gnd PWL 0 'Vgnd'

Vbl1en ENBl1 Gnd PWL 0 'Vgnd'
Vbl2en ENBl2 Gnd PWL 0 'Vgnd' 'TpPulse-1p' 'Vgnd' 'TpPulse' 'Vvdd' '5n' 'Vvdd' '5n+1p' 'Vgnd' '5n+TpWrite-1p' 'Vgnd' '5n+TpWrite' 'Vvdd' '7n-1p' 'Vvdd' '7n' 'Vgnd' '8n+TpRead-1p' 'Vgnd' '8n+TpRead' 'Vvdd' '9n-1p' 'Vvdd' '9n' 'Vgnd'
Vbl3en ENBl3 Gnd PWL 0 'Vgnd'
Vbl4en ENBl4 Gnd PWL 0 'Vgnd'

Vvdd Vdd Gnd 'Vvdd'

* Bitcell

X1 WL1 NM1 MTJT
Vtest1 BL1 NM1 0
X2 WL1 NM2 MTJT
Vtest2 BL2 NM2 0
X3 WL1 NM3 MTJT
Vtest3 BL3 NM3 0
X4 WL1 NM4 MTJT
Vtest4 BL4 NM4 0
X5 WL2 NM5 MTJT
Vtest5 BL1 NM5 0
X6 WL2 NM6 MTJT
Vtest6 BL2 NM6 0
X7 WL2 NM7 MTJT
Vtest7 BL3 NM7 0
X8 WL2 NM8 MTJT
Vtest8 BL4 NM8 0
X9 WL3 NM9 MTJT
Vtest9 BL1 NM9 0
X10 WL3 NM10 MTJT
Vtest10 BL2 NM10 0
X11 WL3 NM11 MTJT
Vtest11 BL3 NM11 0
X12 WL3 NM12 MTJT
Vtest12 BL4 NM12 0
X13 WL4 NM13 MTJT
Vtest13 BL1 NM13 0
X14 WL4 NM14 MTJT
Vtest14 BL2 NM14 0
X15 WL4 NM15 MTJT
Vtest15 BL3 NM15 0
X16 WL4 NM16 MTJT
Vtest16 BL4 NM16 0

* Tristate

X18 WL1T WL1 ENBl1 Vdd Gnd TG
X22 BL1T BL1 ENBl1 Vdd Gnd TG
X19 WL2T WL2 ENBl2 Vdd Gnd TG
X23 BL2T BL2 ENBl2 Vdd Gnd TG
X20 WL3T WL3 ENBl3 Vdd Gnd TG
X24 BL3T BL3 ENBl3 Vdd Gnd TG
X21 WL4T WL4 ENBl4 Vdd Gnd TG
X25 BL4T BL4 ENBl4 Vdd Gnd TG

* Bitlines Capacitance

Cbl26 BL1 Gnd 'cap'
Cbl27 BL2 Gnd 'cap'
Cbl28 BL3 Gnd 'cap'
Cbl29 BL4 Gnd 'cap'

.TRAN 1p 10n

.option rawfmt="psfbin"
