* Crossbar one bit

simulator lang=spice

.include '45nm_LP.pm'
.include 'MTJT.spi'
.include 'TRANSGATE.spi'

.param cap = 1.5f

.param Vvdd = 1.6

.param Vgnd = 0

.param Vread = 1

.param TpWrite = 0.7n
.param TpRead = 0.3n
.param TpPulse = 0.9n

Vwl1 WL1T Gnd PWL 0 'Vgnd'
Vwl2 WL2T Gnd PWL 0 'Vgnd'
Vwl3 WL3T Gnd PWL 0 'Vgnd'
Vwl4 WL4T Gnd PWL 0 'Vgnd' 'TpPulse-1p' 'Vgnd' 'TpPulse' 'Vvdd' '5n' 'Vvdd' '5n+1p' 'Vgnd' '8n+TpRead' 'Vgnd' '8n+TpRead+1p' 'Vread' '9n-1p' 'Vread' '9n' 'Vgnd'
Vwl5 WL5T Gnd PWL 0 'Vgnd'
Vwl6 WL6T Gnd PWL 0 'Vgnd'
Vwl7 WL7T Gnd PWL 0 'Vgnd'
Vwl8 WL8T Gnd PWL 0 'Vgnd'

Vbl1 BL1T Gnd PWL 0 'Vgnd'
Vbl2 BL2T Gnd PWL 0 'Vgnd'
Vbl3 BL3T Gnd PWL 0 'Vgnd'
Vbl4 BL4T Gnd PWL 0 'Vgnd'
Vbl5 BL5T Gnd PWL 0 'Vgnd'
Vbl6 BL6T Gnd PWL 0 'Vgnd'
Vbl7 BL7T Gnd PWL 0 'Vgnd'
Vbl8 BL8T Gnd PWL 0 'Vgnd'
Vbl9 BL9T Gnd PWL 0 'Vgnd'
Vbl10 BL10T Gnd PWL 0 'Vgnd'
Vbl11 BL11T Gnd PWL 0 'Vgnd'
Vbl12 BL12T Gnd PWL 0 'Vgnd'
Vbl13 BL13T Gnd PWL 0 'Vgnd'
Vbl14 BL14T Gnd PWL 0 'Vgnd'
Vbl15 BL15T Gnd PWL 0 'Vgnd'
Vbl16 BL16T Gnd PWL 0 'Vgnd' '5n+TpWrite-1p' 'Vgnd' '5n+TpWrite' 'Vvdd' '7n-1p' 'Vvdd' '7n' 'Vgnd'
Vbl17 BL17T Gnd PWL 0 'Vgnd'
Vbl18 BL18T Gnd PWL 0 'Vgnd'
Vbl19 BL19T Gnd PWL 0 'Vgnd'
Vbl20 BL20T Gnd PWL 0 'Vgnd'
Vbl21 BL21T Gnd PWL 0 'Vgnd'
Vbl22 BL22T Gnd PWL 0 'Vgnd'
Vbl23 BL23T Gnd PWL 0 'Vgnd'
Vbl24 BL24T Gnd PWL 0 'Vgnd'
Vbl25 BL25T Gnd PWL 0 'Vgnd'
Vbl26 BL26T Gnd PWL 0 'Vgnd'
Vbl27 BL27T Gnd PWL 0 'Vgnd'
Vbl28 BL28T Gnd PWL 0 'Vgnd'
Vbl29 BL29T Gnd PWL 0 'Vgnd'
Vbl30 BL30T Gnd PWL 0 'Vgnd'
Vbl31 BL31T Gnd PWL 0 'Vgnd'
Vbl32 BL32T Gnd PWL 0 'Vgnd'

Vwl1en ENWl1 Gnd PWL 0 'Vgnd'
Vwl2en ENWl2 Gnd PWL 0 'Vgnd'
Vwl3en ENWl3 Gnd PWL 0 'Vgnd'
Vwl4en ENWl4 Gnd PWL 0 'Vgnd' 'TpPulse-1p' 'Vgnd' 'TpPulse' 'Vvdd' '5n' 'Vvdd' '5n+1p' 'Vgnd' '5n+TpWrite-1p' 'Vgnd' '5n+TpWrite' 'Vvdd' '7n-1p' 'Vvdd' '7n' 'Vgnd' '8n+TpRead-1p' 'Vgnd' '8n+TpRead' 'Vvdd' '9n-1p' 'Vvdd' '9n' 'Vgnd'
Vwl5en ENWl5 Gnd PWL 0 'Vgnd'
Vwl6en ENWl6 Gnd PWL 0 'Vgnd'
Vwl7en ENWl7 Gnd PWL 0 'Vgnd'
Vwl8en ENWl8 Gnd PWL 0 'Vgnd'

Vbl1en ENBl1 Gnd PWL 0 'Vgnd'
Vbl2en ENBl2 Gnd PWL 0 'Vgnd'
Vbl3en ENBl3 Gnd PWL 0 'Vgnd'
Vbl4en ENBl4 Gnd PWL 0 'Vgnd'
Vbl5en ENBl5 Gnd PWL 0 'Vgnd'
Vbl6en ENBl6 Gnd PWL 0 'Vgnd'
Vbl7en ENBl7 Gnd PWL 0 'Vgnd'
Vbl8en ENBl8 Gnd PWL 0 'Vgnd'
Vbl9en ENBl9 Gnd PWL 0 'Vgnd'
Vbl10en ENBl10 Gnd PWL 0 'Vgnd'
Vbl11en ENBl11 Gnd PWL 0 'Vgnd'
Vbl12en ENBl12 Gnd PWL 0 'Vgnd'
Vbl13en ENBl13 Gnd PWL 0 'Vgnd'
Vbl14en ENBl14 Gnd PWL 0 'Vgnd'
Vbl15en ENBl15 Gnd PWL 0 'Vgnd'
Vbl16en ENBl16 Gnd PWL 0 'Vgnd' 'TpPulse-1p' 'Vgnd' 'TpPulse' 'Vvdd' '5n' 'Vvdd' '5n+1p' 'Vgnd' '5n+TpWrite-1p' 'Vgnd' '5n+TpWrite' 'Vvdd' '7n-1p' 'Vvdd' '7n' 'Vgnd' '8n+TpRead-1p' 'Vgnd' '8n+TpRead' 'Vvdd' '9n-1p' 'Vvdd' '9n' 'Vgnd'
Vbl17en ENBl17 Gnd PWL 0 'Vgnd'
Vbl18en ENBl18 Gnd PWL 0 'Vgnd'
Vbl19en ENBl19 Gnd PWL 0 'Vgnd'
Vbl20en ENBl20 Gnd PWL 0 'Vgnd'
Vbl21en ENBl21 Gnd PWL 0 'Vgnd'
Vbl22en ENBl22 Gnd PWL 0 'Vgnd'
Vbl23en ENBl23 Gnd PWL 0 'Vgnd'
Vbl24en ENBl24 Gnd PWL 0 'Vgnd'
Vbl25en ENBl25 Gnd PWL 0 'Vgnd'
Vbl26en ENBl26 Gnd PWL 0 'Vgnd'
Vbl27en ENBl27 Gnd PWL 0 'Vgnd'
Vbl28en ENBl28 Gnd PWL 0 'Vgnd'
Vbl29en ENBl29 Gnd PWL 0 'Vgnd'
Vbl30en ENBl30 Gnd PWL 0 'Vgnd'
Vbl31en ENBl31 Gnd PWL 0 'Vgnd'
Vbl32en ENBl32 Gnd PWL 0 'Vgnd'

Vvdd Vdd Gnd 'Vvdd'

* Bitcell

X1 WL1 NM1 MTJT
Vtest1 BL1 NM1 0

X2 WL1 NM2 MTJT
Vtest2 BL2 NM2 0

X3 WL1 NM3 MTJT
Vtest3 BL3 NM3 0

X4 WL1 NM4 MTJT
Vtest4 BL4 NM4 0

X5 WL1 NM5 MTJT
Vtest5 BL5 NM5 0

X6 WL1 NM6 MTJT
Vtest6 BL6 NM6 0

X7 WL1 NM7 MTJT
Vtest7 BL7 NM7 0

X8 WL1 NM8 MTJT
Vtest8 BL8 NM8 0

X9 WL1 NM9 MTJT
Vtest9 BL9 NM9 0

X10 WL1 NM10 MTJT
Vtest10 BL10 NM10 0

X11 WL1 NM11 MTJT
Vtest11 BL11 NM11 0

X12 WL1 NM12 MTJT
Vtest12 BL12 NM12 0

X13 WL1 NM13 MTJT
Vtest13 BL13 NM13 0

X14 WL1 NM14 MTJT
Vtest14 BL14 NM14 0

X15 WL1 NM15 MTJT
Vtest15 BL15 NM15 0

X16 WL1 NM16 MTJT
Vtest16 BL16 NM16 0

X17 WL1 NM17 MTJT
Vtest17 BL17 NM17 0

X18 WL1 NM18 MTJT
Vtest18 BL18 NM18 0

X19 WL1 NM19 MTJT
Vtest19 BL19 NM19 0

X20 WL1 NM20 MTJT
Vtest20 BL20 NM20 0

X21 WL1 NM21 MTJT
Vtest21 BL21 NM21 0

X22 WL1 NM22 MTJT
Vtest22 BL22 NM22 0

X23 WL1 NM23 MTJT
Vtest23 BL23 NM23 0

X24 WL1 NM24 MTJT
Vtest24 BL24 NM24 0

X25 WL1 NM25 MTJT
Vtest25 BL25 NM25 0

X26 WL1 NM26 MTJT
Vtest26 BL26 NM26 0

X27 WL1 NM27 MTJT
Vtest27 BL27 NM27 0

X28 WL1 NM28 MTJT
Vtest28 BL28 NM28 0

X29 WL1 NM29 MTJT
Vtest29 BL29 NM29 0

X30 WL1 NM30 MTJT
Vtest30 BL30 NM30 0

X31 WL1 NM31 MTJT
Vtest31 BL31 NM31 0

X32 WL1 NM32 MTJT
Vtest32 BL32 NM32 0

X33 WL2 NM33 MTJT
Vtest33 BL1 NM33 0

X34 WL2 NM34 MTJT
Vtest34 BL2 NM34 0

X35 WL2 NM35 MTJT
Vtest35 BL3 NM35 0

X36 WL2 NM36 MTJT
Vtest36 BL4 NM36 0

X37 WL2 NM37 MTJT
Vtest37 BL5 NM37 0

X38 WL2 NM38 MTJT
Vtest38 BL6 NM38 0

X39 WL2 NM39 MTJT
Vtest39 BL7 NM39 0

X40 WL2 NM40 MTJT
Vtest40 BL8 NM40 0

X41 WL2 NM41 MTJT
Vtest41 BL9 NM41 0

X42 WL2 NM42 MTJT
Vtest42 BL10 NM42 0

X43 WL2 NM43 MTJT
Vtest43 BL11 NM43 0

X44 WL2 NM44 MTJT
Vtest44 BL12 NM44 0

X45 WL2 NM45 MTJT
Vtest45 BL13 NM45 0

X46 WL2 NM46 MTJT
Vtest46 BL14 NM46 0

X47 WL2 NM47 MTJT
Vtest47 BL15 NM47 0

X48 WL2 NM48 MTJT
Vtest48 BL16 NM48 0

X49 WL2 NM49 MTJT
Vtest49 BL17 NM49 0

X50 WL2 NM50 MTJT
Vtest50 BL18 NM50 0

X51 WL2 NM51 MTJT
Vtest51 BL19 NM51 0

X52 WL2 NM52 MTJT
Vtest52 BL20 NM52 0

X53 WL2 NM53 MTJT
Vtest53 BL21 NM53 0

X54 WL2 NM54 MTJT
Vtest54 BL22 NM54 0

X55 WL2 NM55 MTJT
Vtest55 BL23 NM55 0

X56 WL2 NM56 MTJT
Vtest56 BL24 NM56 0

X57 WL2 NM57 MTJT
Vtest57 BL25 NM57 0

X58 WL2 NM58 MTJT
Vtest58 BL26 NM58 0

X59 WL2 NM59 MTJT
Vtest59 BL27 NM59 0

X60 WL2 NM60 MTJT
Vtest60 BL28 NM60 0

X61 WL2 NM61 MTJT
Vtest61 BL29 NM61 0

X62 WL2 NM62 MTJT
Vtest62 BL30 NM62 0

X63 WL2 NM63 MTJT
Vtest63 BL31 NM63 0

X64 WL2 NM64 MTJT
Vtest64 BL32 NM64 0

X65 WL3 NM65 MTJT
Vtest65 BL1 NM65 0

X66 WL3 NM66 MTJT
Vtest66 BL2 NM66 0

X67 WL3 NM67 MTJT
Vtest67 BL3 NM67 0

X68 WL3 NM68 MTJT
Vtest68 BL4 NM68 0

X69 WL3 NM69 MTJT
Vtest69 BL5 NM69 0

X70 WL3 NM70 MTJT
Vtest70 BL6 NM70 0

X71 WL3 NM71 MTJT
Vtest71 BL7 NM71 0

X72 WL3 NM72 MTJT
Vtest72 BL8 NM72 0

X73 WL3 NM73 MTJT
Vtest73 BL9 NM73 0

X74 WL3 NM74 MTJT
Vtest74 BL10 NM74 0

X75 WL3 NM75 MTJT
Vtest75 BL11 NM75 0

X76 WL3 NM76 MTJT
Vtest76 BL12 NM76 0

X77 WL3 NM77 MTJT
Vtest77 BL13 NM77 0

X78 WL3 NM78 MTJT
Vtest78 BL14 NM78 0

X79 WL3 NM79 MTJT
Vtest79 BL15 NM79 0

X80 WL3 NM80 MTJT
Vtest80 BL16 NM80 0

X81 WL3 NM81 MTJT
Vtest81 BL17 NM81 0

X82 WL3 NM82 MTJT
Vtest82 BL18 NM82 0

X83 WL3 NM83 MTJT
Vtest83 BL19 NM83 0

X84 WL3 NM84 MTJT
Vtest84 BL20 NM84 0

X85 WL3 NM85 MTJT
Vtest85 BL21 NM85 0

X86 WL3 NM86 MTJT
Vtest86 BL22 NM86 0

X87 WL3 NM87 MTJT
Vtest87 BL23 NM87 0

X88 WL3 NM88 MTJT
Vtest88 BL24 NM88 0

X89 WL3 NM89 MTJT
Vtest89 BL25 NM89 0

X90 WL3 NM90 MTJT
Vtest90 BL26 NM90 0

X91 WL3 NM91 MTJT
Vtest91 BL27 NM91 0

X92 WL3 NM92 MTJT
Vtest92 BL28 NM92 0

X93 WL3 NM93 MTJT
Vtest93 BL29 NM93 0

X94 WL3 NM94 MTJT
Vtest94 BL30 NM94 0

X95 WL3 NM95 MTJT
Vtest95 BL31 NM95 0

X96 WL3 NM96 MTJT
Vtest96 BL32 NM96 0

X97 WL4 NM97 MTJT
Vtest97 BL1 NM97 0

X98 WL4 NM98 MTJT
Vtest98 BL2 NM98 0

X99 WL4 NM99 MTJT
Vtest99 BL3 NM99 0

X100 WL4 NM100 MTJT
Vtest100 BL4 NM100 0

X101 WL4 NM101 MTJT
Vtest101 BL5 NM101 0

X102 WL4 NM102 MTJT
Vtest102 BL6 NM102 0

X103 WL4 NM103 MTJT
Vtest103 BL7 NM103 0

X104 WL4 NM104 MTJT
Vtest104 BL8 NM104 0

X105 WL4 NM105 MTJT
Vtest105 BL9 NM105 0

X106 WL4 NM106 MTJT
Vtest106 BL10 NM106 0

X107 WL4 NM107 MTJT
Vtest107 BL11 NM107 0

X108 WL4 NM108 MTJT
Vtest108 BL12 NM108 0

X109 WL4 NM109 MTJT
Vtest109 BL13 NM109 0

X110 WL4 NM110 MTJT
Vtest110 BL14 NM110 0

X111 WL4 NM111 MTJT
Vtest111 BL15 NM111 0

X112 WL4 NM112 MTJT
Vtest112 BL16 NM112 0

X113 WL4 NM113 MTJT
Vtest113 BL17 NM113 0

X114 WL4 NM114 MTJT
Vtest114 BL18 NM114 0

X115 WL4 NM115 MTJT
Vtest115 BL19 NM115 0

X116 WL4 NM116 MTJT
Vtest116 BL20 NM116 0

X117 WL4 NM117 MTJT
Vtest117 BL21 NM117 0

X118 WL4 NM118 MTJT
Vtest118 BL22 NM118 0

X119 WL4 NM119 MTJT
Vtest119 BL23 NM119 0

X120 WL4 NM120 MTJT
Vtest120 BL24 NM120 0

X121 WL4 NM121 MTJT
Vtest121 BL25 NM121 0

X122 WL4 NM122 MTJT
Vtest122 BL26 NM122 0

X123 WL4 NM123 MTJT
Vtest123 BL27 NM123 0

X124 WL4 NM124 MTJT
Vtest124 BL28 NM124 0

X125 WL4 NM125 MTJT
Vtest125 BL29 NM125 0

X126 WL4 NM126 MTJT
Vtest126 BL30 NM126 0

X127 WL4 NM127 MTJT
Vtest127 BL31 NM127 0

X128 WL4 NM128 MTJT
Vtest128 BL32 NM128 0

X129 WL5 NM129 MTJT
Vtest129 BL1 NM129 0

X130 WL5 NM130 MTJT
Vtest130 BL2 NM130 0

X131 WL5 NM131 MTJT
Vtest131 BL3 NM131 0

X132 WL5 NM132 MTJT
Vtest132 BL4 NM132 0

X133 WL5 NM133 MTJT
Vtest133 BL5 NM133 0

X134 WL5 NM134 MTJT
Vtest134 BL6 NM134 0

X135 WL5 NM135 MTJT
Vtest135 BL7 NM135 0

X136 WL5 NM136 MTJT
Vtest136 BL8 NM136 0

X137 WL5 NM137 MTJT
Vtest137 BL9 NM137 0

X138 WL5 NM138 MTJT
Vtest138 BL10 NM138 0

X139 WL5 NM139 MTJT
Vtest139 BL11 NM139 0

X140 WL5 NM140 MTJT
Vtest140 BL12 NM140 0

X141 WL5 NM141 MTJT
Vtest141 BL13 NM141 0

X142 WL5 NM142 MTJT
Vtest142 BL14 NM142 0

X143 WL5 NM143 MTJT
Vtest143 BL15 NM143 0

X144 WL5 NM144 MTJT
Vtest144 BL16 NM144 0

X145 WL5 NM145 MTJT
Vtest145 BL17 NM145 0

X146 WL5 NM146 MTJT
Vtest146 BL18 NM146 0

X147 WL5 NM147 MTJT
Vtest147 BL19 NM147 0

X148 WL5 NM148 MTJT
Vtest148 BL20 NM148 0

X149 WL5 NM149 MTJT
Vtest149 BL21 NM149 0

X150 WL5 NM150 MTJT
Vtest150 BL22 NM150 0

X151 WL5 NM151 MTJT
Vtest151 BL23 NM151 0

X152 WL5 NM152 MTJT
Vtest152 BL24 NM152 0

X153 WL5 NM153 MTJT
Vtest153 BL25 NM153 0

X154 WL5 NM154 MTJT
Vtest154 BL26 NM154 0

X155 WL5 NM155 MTJT
Vtest155 BL27 NM155 0

X156 WL5 NM156 MTJT
Vtest156 BL28 NM156 0

X157 WL5 NM157 MTJT
Vtest157 BL29 NM157 0

X158 WL5 NM158 MTJT
Vtest158 BL30 NM158 0

X159 WL5 NM159 MTJT
Vtest159 BL31 NM159 0

X160 WL5 NM160 MTJT
Vtest160 BL32 NM160 0

X161 WL6 NM161 MTJT
Vtest161 BL1 NM161 0

X162 WL6 NM162 MTJT
Vtest162 BL2 NM162 0

X163 WL6 NM163 MTJT
Vtest163 BL3 NM163 0

X164 WL6 NM164 MTJT
Vtest164 BL4 NM164 0

X165 WL6 NM165 MTJT
Vtest165 BL5 NM165 0

X166 WL6 NM166 MTJT
Vtest166 BL6 NM166 0

X167 WL6 NM167 MTJT
Vtest167 BL7 NM167 0

X168 WL6 NM168 MTJT
Vtest168 BL8 NM168 0

X169 WL6 NM169 MTJT
Vtest169 BL9 NM169 0

X170 WL6 NM170 MTJT
Vtest170 BL10 NM170 0

X171 WL6 NM171 MTJT
Vtest171 BL11 NM171 0

X172 WL6 NM172 MTJT
Vtest172 BL12 NM172 0

X173 WL6 NM173 MTJT
Vtest173 BL13 NM173 0

X174 WL6 NM174 MTJT
Vtest174 BL14 NM174 0

X175 WL6 NM175 MTJT
Vtest175 BL15 NM175 0

X176 WL6 NM176 MTJT
Vtest176 BL16 NM176 0

X177 WL6 NM177 MTJT
Vtest177 BL17 NM177 0

X178 WL6 NM178 MTJT
Vtest178 BL18 NM178 0

X179 WL6 NM179 MTJT
Vtest179 BL19 NM179 0

X180 WL6 NM180 MTJT
Vtest180 BL20 NM180 0

X181 WL6 NM181 MTJT
Vtest181 BL21 NM181 0

X182 WL6 NM182 MTJT
Vtest182 BL22 NM182 0

X183 WL6 NM183 MTJT
Vtest183 BL23 NM183 0

X184 WL6 NM184 MTJT
Vtest184 BL24 NM184 0

X185 WL6 NM185 MTJT
Vtest185 BL25 NM185 0

X186 WL6 NM186 MTJT
Vtest186 BL26 NM186 0

X187 WL6 NM187 MTJT
Vtest187 BL27 NM187 0

X188 WL6 NM188 MTJT
Vtest188 BL28 NM188 0

X189 WL6 NM189 MTJT
Vtest189 BL29 NM189 0

X190 WL6 NM190 MTJT
Vtest190 BL30 NM190 0

X191 WL6 NM191 MTJT
Vtest191 BL31 NM191 0

X192 WL6 NM192 MTJT
Vtest192 BL32 NM192 0

X193 WL7 NM193 MTJT
Vtest193 BL1 NM193 0

X194 WL7 NM194 MTJT
Vtest194 BL2 NM194 0

X195 WL7 NM195 MTJT
Vtest195 BL3 NM195 0

X196 WL7 NM196 MTJT
Vtest196 BL4 NM196 0

X197 WL7 NM197 MTJT
Vtest197 BL5 NM197 0

X198 WL7 NM198 MTJT
Vtest198 BL6 NM198 0

X199 WL7 NM199 MTJT
Vtest199 BL7 NM199 0

X200 WL7 NM200 MTJT
Vtest200 BL8 NM200 0

X201 WL7 NM201 MTJT
Vtest201 BL9 NM201 0

X202 WL7 NM202 MTJT
Vtest202 BL10 NM202 0

X203 WL7 NM203 MTJT
Vtest203 BL11 NM203 0

X204 WL7 NM204 MTJT
Vtest204 BL12 NM204 0

X205 WL7 NM205 MTJT
Vtest205 BL13 NM205 0

X206 WL7 NM206 MTJT
Vtest206 BL14 NM206 0

X207 WL7 NM207 MTJT
Vtest207 BL15 NM207 0

X208 WL7 NM208 MTJT
Vtest208 BL16 NM208 0

X209 WL7 NM209 MTJT
Vtest209 BL17 NM209 0

X210 WL7 NM210 MTJT
Vtest210 BL18 NM210 0

X211 WL7 NM211 MTJT
Vtest211 BL19 NM211 0

X212 WL7 NM212 MTJT
Vtest212 BL20 NM212 0

X213 WL7 NM213 MTJT
Vtest213 BL21 NM213 0

X214 WL7 NM214 MTJT
Vtest214 BL22 NM214 0

X215 WL7 NM215 MTJT
Vtest215 BL23 NM215 0

X216 WL7 NM216 MTJT
Vtest216 BL24 NM216 0

X217 WL7 NM217 MTJT
Vtest217 BL25 NM217 0

X218 WL7 NM218 MTJT
Vtest218 BL26 NM218 0

X219 WL7 NM219 MTJT
Vtest219 BL27 NM219 0

X220 WL7 NM220 MTJT
Vtest220 BL28 NM220 0

X221 WL7 NM221 MTJT
Vtest221 BL29 NM221 0

X222 WL7 NM222 MTJT
Vtest222 BL30 NM222 0

X223 WL7 NM223 MTJT
Vtest223 BL31 NM223 0

X224 WL7 NM224 MTJT
Vtest224 BL32 NM224 0

X225 WL8 NM225 MTJT
Vtest225 BL1 NM225 0

X226 WL8 NM226 MTJT
Vtest226 BL2 NM226 0

X227 WL8 NM227 MTJT
Vtest227 BL3 NM227 0

X228 WL8 NM228 MTJT
Vtest228 BL4 NM228 0

X229 WL8 NM229 MTJT
Vtest229 BL5 NM229 0

X230 WL8 NM230 MTJT
Vtest230 BL6 NM230 0

X231 WL8 NM231 MTJT
Vtest231 BL7 NM231 0

X232 WL8 NM232 MTJT
Vtest232 BL8 NM232 0

X233 WL8 NM233 MTJT
Vtest233 BL9 NM233 0

X234 WL8 NM234 MTJT
Vtest234 BL10 NM234 0

X235 WL8 NM235 MTJT
Vtest235 BL11 NM235 0

X236 WL8 NM236 MTJT
Vtest236 BL12 NM236 0

X237 WL8 NM237 MTJT
Vtest237 BL13 NM237 0

X238 WL8 NM238 MTJT
Vtest238 BL14 NM238 0

X239 WL8 NM239 MTJT
Vtest239 BL15 NM239 0

X240 WL8 NM240 MTJT
Vtest240 BL16 NM240 0

X241 WL8 NM241 MTJT
Vtest241 BL17 NM241 0

X242 WL8 NM242 MTJT
Vtest242 BL18 NM242 0

X243 WL8 NM243 MTJT
Vtest243 BL19 NM243 0

X244 WL8 NM244 MTJT
Vtest244 BL20 NM244 0

X245 WL8 NM245 MTJT
Vtest245 BL21 NM245 0

X246 WL8 NM246 MTJT
Vtest246 BL22 NM246 0

X247 WL8 NM247 MTJT
Vtest247 BL23 NM247 0

X248 WL8 NM248 MTJT
Vtest248 BL24 NM248 0

X249 WL8 NM249 MTJT
Vtest249 BL25 NM249 0

X250 WL8 NM250 MTJT
Vtest250 BL26 NM250 0

X251 WL8 NM251 MTJT
Vtest251 BL27 NM251 0

X252 WL8 NM252 MTJT
Vtest252 BL28 NM252 0

X253 WL8 NM253 MTJT
Vtest253 BL29 NM253 0

X254 WL8 NM254 MTJT
Vtest254 BL30 NM254 0

X255 WL8 NM255 MTJT
Vtest255 BL31 NM255 0

X256 WL8 NM256 MTJT
Vtest256 BL32 NM256 0

* Tristate

X258 WL1T WL1 ENWl1 Vdd Gnd TG
X259 WL2T WL2 ENWl2 Vdd Gnd TG
X260 WL3T WL3 ENWl3 Vdd Gnd TG
X261 WL4T WL4 ENWl4 Vdd Gnd TG
X262 WL5T WL5 ENWl5 Vdd Gnd TG
X263 WL6T WL6 ENWl6 Vdd Gnd TG
X264 WL7T WL7 ENWl7 Vdd Gnd TG
X265 WL8T WL8 ENWl8 Vdd Gnd TG
X267 BL1T BL1 ENBl1 Vdd Gnd TG
X268 BL2T BL2 ENBl2 Vdd Gnd TG
X269 BL3T BL3 ENBl3 Vdd Gnd TG
X270 BL4T BL4 ENBl4 Vdd Gnd TG
X271 BL5T BL5 ENBl5 Vdd Gnd TG
X272 BL6T BL6 ENBl6 Vdd Gnd TG
X273 BL7T BL7 ENBl7 Vdd Gnd TG
X274 BL8T BL8 ENBl8 Vdd Gnd TG
X275 BL9T BL9 ENBl9 Vdd Gnd TG
X276 BL10T BL10 ENBl10 Vdd Gnd TG
X277 BL11T BL11 ENBl11 Vdd Gnd TG
X278 BL12T BL12 ENBl12 Vdd Gnd TG
X279 BL13T BL13 ENBl13 Vdd Gnd TG
X280 BL14T BL14 ENBl14 Vdd Gnd TG
X281 BL15T BL15 ENBl15 Vdd Gnd TG
X282 BL16T BL16 ENBl16 Vdd Gnd TG
X283 BL17T BL17 ENBl17 Vdd Gnd TG
X284 BL18T BL18 ENBl18 Vdd Gnd TG
X285 BL19T BL19 ENBl19 Vdd Gnd TG
X286 BL20T BL20 ENBl20 Vdd Gnd TG
X287 BL21T BL21 ENBl21 Vdd Gnd TG
X288 BL22T BL22 ENBl22 Vdd Gnd TG
X289 BL23T BL23 ENBl23 Vdd Gnd TG
X290 BL24T BL24 ENBl24 Vdd Gnd TG
X291 BL25T BL25 ENBl25 Vdd Gnd TG
X292 BL26T BL26 ENBl26 Vdd Gnd TG
X293 BL27T BL27 ENBl27 Vdd Gnd TG
X294 BL28T BL28 ENBl28 Vdd Gnd TG
X295 BL29T BL29 ENBl29 Vdd Gnd TG
X296 BL30T BL30 ENBl30 Vdd Gnd TG
X297 BL31T BL31 ENBl31 Vdd Gnd TG
X298 BL32T BL32 ENBl32 Vdd Gnd TG

* Bitlines Capacitance

Cbl322 BL1 Gnd 'cap'
Cbl323 BL2 Gnd 'cap'
Cbl324 BL3 Gnd 'cap'
Cbl325 BL4 Gnd 'cap'
Cbl326 BL5 Gnd 'cap'
Cbl327 BL6 Gnd 'cap'
Cbl328 BL7 Gnd 'cap'
Cbl329 BL8 Gnd 'cap'
Cbl330 BL9 Gnd 'cap'
Cbl331 BL10 Gnd 'cap'
Cbl332 BL11 Gnd 'cap'
Cbl333 BL12 Gnd 'cap'
Cbl334 BL13 Gnd 'cap'
Cbl335 BL14 Gnd 'cap'
Cbl336 BL15 Gnd 'cap'
Cbl337 BL16 Gnd 'cap'
Cbl338 BL17 Gnd 'cap'
Cbl339 BL18 Gnd 'cap'
Cbl340 BL19 Gnd 'cap'
Cbl341 BL20 Gnd 'cap'
Cbl342 BL21 Gnd 'cap'
Cbl343 BL22 Gnd 'cap'
Cbl344 BL23 Gnd 'cap'
Cbl345 BL24 Gnd 'cap'
Cbl346 BL25 Gnd 'cap'
Cbl347 BL26 Gnd 'cap'
Cbl348 BL27 Gnd 'cap'
Cbl349 BL28 Gnd 'cap'
Cbl350 BL29 Gnd 'cap'
Cbl351 BL30 Gnd 'cap'
Cbl352 BL31 Gnd 'cap'
Cbl353 BL32 Gnd 'cap'

.TRAN 1p 10n

.option rawfmt="psfbin"
