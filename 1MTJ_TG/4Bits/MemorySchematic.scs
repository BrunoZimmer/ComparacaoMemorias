* Crossbar one bit

simulator lang=spice

.include '45nm_LP.pm'
.include 'MTJT.spi'
.include 'TRANSGATE.spi'

.param cap = 0.5f

.param Vvdd = 1.6

.param Vgnd = 0

.param Vread = 1

.param TpWrite = 0.9n
.param TpRead = 0.3n
.param TpPulse = 0.9n

* Wordlines controller
Vwl1 WL1T Gnd PWL 0 'Vgnd' 'TpPulse-1p' 'Vgnd' 'TpPulse' 'Vvdd' '5n' 'Vvdd' '5n+1p' 'Vgnd' '8n+TpRead-1p' 'Vgnd' '8n+TpRead' 'Vread' '9n-1p' 'Vread' '9n' 'Vgnd'
Vwl2 WL2T Gnd PWL 0 'Vgnd'

*Bitlines controller
Vbl1 BL1T Gnd PWL 0 'Vgnd' '5n+TpWrite-1p' 'Vgnd' '5n+TpWrite' 'Vvdd' '7n-1p' 'Vvdd' '7n' 'Vgnd'
Vbl2 BL2T Gnd PWL 0 'Vgnd'

*En controller
Vbl1en ENBl1 Gnd PWL 0 1
Vbl2en ENBl2 Gnd PWL 0 0

Vvdd Vdd Gnd 'Vvdd'

* Bitcell
*R1 WL1 BL1 1k
X1 WL1 NM1 MTJT
Vtest1 BL1 NM1 0

X2 WL1 NM2 MTJT
Vtest2 BL2 NM2 0

X3 WL2 NM3 MTJT
Vtest3 BL1 NM3 0

X4 WL2 NM4 MTJT
Vtest4 BL2 NM4 0

*Tristate

X5 WL1T WL1 ENBl1 Vdd Gnd TG
X6 WL2T WL2 ENBl2 Vdd Gnd TG
X7 BL1T BL1 ENBl1 Vdd Gnd TG
X8 BL2T BL2 ENBl2 Vdd Gnd TG

*Bitlines Capacitance
Cbl1 BL1 Gnd 'cap'
Cbl2 BL2 Gnd 'cap'

.TRAN 1p 10n

.option rawfmt="psfbin"
