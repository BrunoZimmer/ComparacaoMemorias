* Crossbar

simulator lang=spice

.include '45nm_LP.pm'
.include 'MTJT.spi'
.include 'TRANSGATE.spi'

.param cap = 1.5f

.param Vvdd = 1.6

.param Vgnd = 0

.param Vread = 1

.param TpWrite = 0.7n
.param TpRead = 0.3n
.param TpPulse = 0.9n

Vwl1 WL1T Gnd PWL 0 'Vgnd'
Vwl2 WL2T Gnd PWL 0 'Vgnd'
Vwl3 WL3T Gnd PWL 0 'Vgnd'
Vwl4 WL4T Gnd PWL 0 'Vgnd' 'TpPulse-1p' 'Vgnd' 'TpPulse' 'Vvdd' '5n' 'Vvdd' '5n+1p' 'Vgnd' '8n+TpRead' 'Vgnd' '8n+TpRead+1p' 'Vread' '9n-1p' 'Vread' '9n' 'Vgnd'
Vwl5 WL5T Gnd PWL 0 'Vgnd'
Vwl6 WL6T Gnd PWL 0 'Vgnd'
Vwl7 WL7T Gnd PWL 0 'Vgnd'
Vwl8 WL8T Gnd PWL 0 'Vgnd'

Vbl1 BL1T Gnd PWL 0 'Vgnd'
Vbl2 BL2T Gnd PWL 0 'Vgnd'
Vbl3 BL3T Gnd PWL 0 'Vgnd'
Vbl4 BL4T Gnd PWL 0 'Vgnd' '5n+TpWrite-1p' 'Vgnd' '5n+TpWrite' 'Vvdd' '7n-1p' 'Vvdd' '7n' 'Vgnd'
Vbl5 BL5T Gnd PWL 0 'Vgnd'
Vbl6 BL6T Gnd PWL 0 'Vgnd'
Vbl7 BL7T Gnd PWL 0 'Vgnd'
Vbl8 BL8T Gnd PWL 0 'Vgnd'

Vbl1en ENBl1 Gnd PWL 0 'Vgnd'
Vbl2en ENBl2 Gnd PWL 0 'Vgnd'
Vbl3en ENBl3 Gnd PWL 0 'Vgnd'
Vbl4en ENBl4 Gnd PWL 0 'Vgnd' 'TpPulse-1p' 'Vgnd' 'TpPulse' 'Vvdd' '5n' 'Vvdd' '5n+1p' 'Vgnd' '5n+TpWrite-1p' 'Vgnd' '5n+TpWrite' 'Vvdd' '7n-1p' 'Vvdd' '7n' 'Vgnd' '8n+TpRead-1p' 'Vgnd' '8n+TpRead' 'Vvdd' '9n-1p' 'Vvdd' '9n' 'Vgnd'
Vbl5en ENBl5 Gnd PWL 0 'Vgnd'
Vbl6en ENBl6 Gnd PWL 0 'Vgnd'
Vbl7en ENBl7 Gnd PWL 0 'Vgnd'
Vbl8en ENBl8 Gnd PWL 0 'Vgnd'

Vvdd Vdd Gnd 'Vvdd'

* Bitcell

X1 WL1 NM1 MTJT
Vtest1 BL1 NM1 0
X2 WL1 NM2 MTJT
Vtest2 BL2 NM2 0
X3 WL1 NM3 MTJT
Vtest3 BL3 NM3 0
X4 WL1 NM4 MTJT
Vtest4 BL4 NM4 0
X5 WL1 NM5 MTJT
Vtest5 BL5 NM5 0
X6 WL1 NM6 MTJT
Vtest6 BL6 NM6 0
X7 WL1 NM7 MTJT
Vtest7 BL7 NM7 0
X8 WL1 NM8 MTJT
Vtest8 BL8 NM8 0
X9 WL2 NM9 MTJT
Vtest9 BL1 NM9 0
X10 WL2 NM10 MTJT
Vtest10 BL2 NM10 0
X11 WL2 NM11 MTJT
Vtest11 BL3 NM11 0
X12 WL2 NM12 MTJT
Vtest12 BL4 NM12 0
X13 WL2 NM13 MTJT
Vtest13 BL5 NM13 0
X14 WL2 NM14 MTJT
Vtest14 BL6 NM14 0
X15 WL2 NM15 MTJT
Vtest15 BL7 NM15 0
X16 WL2 NM16 MTJT
Vtest16 BL8 NM16 0
X17 WL3 NM17 MTJT
Vtest17 BL1 NM17 0
X18 WL3 NM18 MTJT
Vtest18 BL2 NM18 0
X19 WL3 NM19 MTJT
Vtest19 BL3 NM19 0
X20 WL3 NM20 MTJT
Vtest20 BL4 NM20 0
X21 WL3 NM21 MTJT
Vtest21 BL5 NM21 0
X22 WL3 NM22 MTJT
Vtest22 BL6 NM22 0
X23 WL3 NM23 MTJT
Vtest23 BL7 NM23 0
X24 WL3 NM24 MTJT
Vtest24 BL8 NM24 0
X25 WL4 NM25 MTJT
Vtest25 BL1 NM25 0
X26 WL4 NM26 MTJT
Vtest26 BL2 NM26 0
X27 WL4 NM27 MTJT
Vtest27 BL3 NM27 0
X28 WL4 NM28 MTJT
Vtest28 BL4 NM28 0
X29 WL4 NM29 MTJT
Vtest29 BL5 NM29 0
X30 WL4 NM30 MTJT
Vtest30 BL6 NM30 0
X31 WL4 NM31 MTJT
Vtest31 BL7 NM31 0
X32 WL4 NM32 MTJT
Vtest32 BL8 NM32 0
X33 WL5 NM33 MTJT
Vtest33 BL1 NM33 0
X34 WL5 NM34 MTJT
Vtest34 BL2 NM34 0
X35 WL5 NM35 MTJT
Vtest35 BL3 NM35 0
X36 WL5 NM36 MTJT
Vtest36 BL4 NM36 0
X37 WL5 NM37 MTJT
Vtest37 BL5 NM37 0
X38 WL5 NM38 MTJT
Vtest38 BL6 NM38 0
X39 WL5 NM39 MTJT
Vtest39 BL7 NM39 0
X40 WL5 NM40 MTJT
Vtest40 BL8 NM40 0
X41 WL6 NM41 MTJT
Vtest41 BL1 NM41 0
X42 WL6 NM42 MTJT
Vtest42 BL2 NM42 0
X43 WL6 NM43 MTJT
Vtest43 BL3 NM43 0
X44 WL6 NM44 MTJT
Vtest44 BL4 NM44 0
X45 WL6 NM45 MTJT
Vtest45 BL5 NM45 0
X46 WL6 NM46 MTJT
Vtest46 BL6 NM46 0
X47 WL6 NM47 MTJT
Vtest47 BL7 NM47 0
X48 WL6 NM48 MTJT
Vtest48 BL8 NM48 0
X49 WL7 NM49 MTJT
Vtest49 BL1 NM49 0
X50 WL7 NM50 MTJT
Vtest50 BL2 NM50 0
X51 WL7 NM51 MTJT
Vtest51 BL3 NM51 0
X52 WL7 NM52 MTJT
Vtest52 BL4 NM52 0
X53 WL7 NM53 MTJT
Vtest53 BL5 NM53 0
X54 WL7 NM54 MTJT
Vtest54 BL6 NM54 0
X55 WL7 NM55 MTJT
Vtest55 BL7 NM55 0
X56 WL7 NM56 MTJT
Vtest56 BL8 NM56 0
X57 WL8 NM57 MTJT
Vtest57 BL1 NM57 0
X58 WL8 NM58 MTJT
Vtest58 BL2 NM58 0
X59 WL8 NM59 MTJT
Vtest59 BL3 NM59 0
X60 WL8 NM60 MTJT
Vtest60 BL4 NM60 0
X61 WL8 NM61 MTJT
Vtest61 BL5 NM61 0
X62 WL8 NM62 MTJT
Vtest62 BL6 NM62 0
X63 WL8 NM63 MTJT
Vtest63 BL7 NM63 0
X64 WL8 NM64 MTJT
Vtest64 BL8 NM64 0

* Tristate

X66 WL1T WL1 ENBl1 Vdd Gnd TG
X74 BL1T BL1 ENBl1 Vdd Gnd TG
X67 WL2T WL2 ENBl2 Vdd Gnd TG
X75 BL2T BL2 ENBl2 Vdd Gnd TG
X68 WL3T WL3 ENBl3 Vdd Gnd TG
X76 BL3T BL3 ENBl3 Vdd Gnd TG
X69 WL4T WL4 ENBl4 Vdd Gnd TG
X77 BL4T BL4 ENBl4 Vdd Gnd TG
X70 WL5T WL5 ENBl5 Vdd Gnd TG
X78 BL5T BL5 ENBl5 Vdd Gnd TG
X71 WL6T WL6 ENBl6 Vdd Gnd TG
X79 BL6T BL6 ENBl6 Vdd Gnd TG
X72 WL7T WL7 ENBl7 Vdd Gnd TG
X80 BL7T BL7 ENBl7 Vdd Gnd TG
X73 WL8T WL8 ENBl8 Vdd Gnd TG
X81 BL8T BL8 ENBl8 Vdd Gnd TG

* Bitlines Capacitance

Cbl82 BL1 Gnd 'cap'
Cbl83 BL2 Gnd 'cap'
Cbl84 BL3 Gnd 'cap'
Cbl85 BL4 Gnd 'cap'
Cbl86 BL5 Gnd 'cap'
Cbl87 BL6 Gnd 'cap'
Cbl88 BL7 Gnd 'cap'
Cbl89 BL8 Gnd 'cap'

.TRAN 1p 10n

.option rawfmt="psfbin"
