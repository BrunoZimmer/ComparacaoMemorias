* Crossbar one bit

simulator lang=spice

.include '45nm_LP.pm'
.include 'TRANSGATE.spi'
.include '1T1MBitCell.spi'

.param cap = 1.5f

.param Vvdd = 1.6

.param Vgnd = 0

.param Vread = 0.8

.param TpWord = 0.5n
.param TpWrite = 0.9n
.param TpRead = 0.1n
.param TpPulse = 1n

Vwl1 WL1 Gnd PWL 0 'Vvdd'
Vwl2 WL2 Gnd PWL 0 'Vvdd'
Vwl3 WL3 Gnd PWL 0 'Vvdd'
Vwl4 WL4 Gnd PWL 0 'Vvdd'
Vwl5 WL5 Gnd PWL 0 'Vvdd'
Vwl6 WL6 Gnd PWL 0 'Vvdd'
Vwl7 WL7 Gnd PWL 0 'Vvdd'
Vwl8 WL8 Gnd PWL 0 'Vgnd' 'TpPulse-1p' 'Vgnd' 'TpPulse' 'Vvdd' '5n' 'Vvdd' '5n+1p' 'Vgnd'
Vwl9 WL9 Gnd PWL 0 'Vvdd'
Vwl10 WL10 Gnd PWL 0 'Vvdd'
Vwl11 WL11 Gnd PWL 0 'Vvdd'
Vwl12 WL12 Gnd PWL 0 'Vvdd'
Vwl13 WL13 Gnd PWL 0 'Vvdd'
Vwl14 WL14 Gnd PWL 0 'Vvdd'
Vwl15 WL15 Gnd PWL 0 'Vvdd'
Vwl16 WL16 Gnd PWL 0 'Vvdd'

Vbl1 BL1 Gnd PWL 0 'Vgnd'
Vbl2 BL2 Gnd PWL 0 'Vgnd'
Vbl3 BL3 Gnd PWL 0 'Vgnd'
Vbl4 BL4 Gnd PWL 0 'Vgnd' '5n+TpWrite-1p' 'Vgnd' '5n+TpWrite' 'Vvdd' '7n-1p' 'Vvdd' '7n' 'Vgnd'
Vbl5 BL5 Gnd PWL 0 'Vgnd'
Vbl6 BL6 Gnd PWL 0 'Vgnd'
Vbl7 BL7 Gnd PWL 0 'Vgnd'
Vbl8 BL8 Gnd PWL 0 'Vgnd'

Vsl1 SL1 Gnd PWL 0 'Vgnd'
Vsl2 SL2 Gnd PWL 0 'Vgnd'
Vsl3 SL3 Gnd PWL 0 'Vgnd'
Vsl4 SL4 Gnd PWL 0 'Vgnd' 'TpRead-1p' 'Vgnd' 'TpRead' 'Vvdd' 'TpRead+TpPulse' 'Vvdd' 'TpRead+TpPulse+1p' 'Vgnd' '8n-1p+TpRead' 'Vgnd' '8n+TpRead' 'Vread' '8n+0.8n' 'Vread' '8n+0.8n+1p' 'Vgnd'
Vsl5 SL5 Gnd PWL 0 'Vgnd'
Vsl6 SL6 Gnd PWL 0 'Vgnd'
Vsl7 SL7 Gnd PWL 0 'Vgnd'
Vsl8 SL8 Gnd PWL 0 'Vgnd'

Vbl1en ENBl1 Gnd PWL 0 'Vgnd'
Vbl2en ENBl2 Gnd PWL 0 'Vgnd'
Vbl3en ENBl3 Gnd PWL 0 'Vgnd'
Vbl4en ENBl4 Gnd PWL 0 'Vgnd' 'TpPulse-1p' 'Vgnd' 'TpPulse' 'Vvdd' '5n' 'Vvdd' '5n+1p' 'Vgnd' '5n+TpWrite-1p' 'Vgnd' '5n+TpWrite' 'Vvdd' '7n-1p' 'Vvdd' '7n' 'Vgnd' '8n+TpRead-1p' 'Vgnd' '8n+TpRead' 'Vvdd' '9n-1p' 'Vvdd' '9n' 'Vgnd'
Vbl5en ENBl5 Gnd PWL 0 'Vgnd'
Vbl6en ENBl6 Gnd PWL 0 'Vgnd'
Vbl7en ENBl7 Gnd PWL 0 'Vgnd'
Vbl8en ENBl8 Gnd PWL 0 'Vgnd'

Vvdd Vdd Gnd 'Vvdd'

* Bitcell

X1 NM1 SL1 WL1 BCTM
Vtest1 BL1 NM1 0
X2 NM2 SL1 WL2 BCTM
Vtest2 BL1 NM2 0
X3 NM3 SL1 WL3 BCTM
Vtest3 BL1 NM3 0
X4 NM4 SL1 WL4 BCTM
Vtest4 BL1 NM4 0
X5 NM5 SL1 WL5 BCTM
Vtest5 BL1 NM5 0
X6 NM6 SL1 WL6 BCTM
Vtest6 BL1 NM6 0
X7 NM7 SL1 WL7 BCTM
Vtest7 BL1 NM7 0
X8 NM8 SL1 WL8 BCTM
Vtest8 BL1 NM8 0
X9 NM9 SL1 WL9 BCTM
Vtest9 BL1 NM9 0
X10 NM10 SL1 WL10 BCTM
Vtest10 BL1 NM10 0
X11 NM11 SL1 WL11 BCTM
Vtest11 BL1 NM11 0
X12 NM12 SL1 WL12 BCTM
Vtest12 BL1 NM12 0
X13 NM13 SL1 WL13 BCTM
Vtest13 BL1 NM13 0
X14 NM14 SL1 WL14 BCTM
Vtest14 BL1 NM14 0
X15 NM15 SL1 WL15 BCTM
Vtest15 BL1 NM15 0
X16 NM16 SL1 WL16 BCTM
Vtest16 BL1 NM16 0
X17 NM17 SL2 WL1 BCTM
Vtest17 BL2 NM17 0
X18 NM18 SL2 WL2 BCTM
Vtest18 BL2 NM18 0
X19 NM19 SL2 WL3 BCTM
Vtest19 BL2 NM19 0
X20 NM20 SL2 WL4 BCTM
Vtest20 BL2 NM20 0
X21 NM21 SL2 WL5 BCTM
Vtest21 BL2 NM21 0
X22 NM22 SL2 WL6 BCTM
Vtest22 BL2 NM22 0
X23 NM23 SL2 WL7 BCTM
Vtest23 BL2 NM23 0
X24 NM24 SL2 WL8 BCTM
Vtest24 BL2 NM24 0
X25 NM25 SL2 WL9 BCTM
Vtest25 BL2 NM25 0
X26 NM26 SL2 WL10 BCTM
Vtest26 BL2 NM26 0
X27 NM27 SL2 WL11 BCTM
Vtest27 BL2 NM27 0
X28 NM28 SL2 WL12 BCTM
Vtest28 BL2 NM28 0
X29 NM29 SL2 WL13 BCTM
Vtest29 BL2 NM29 0
X30 NM30 SL2 WL14 BCTM
Vtest30 BL2 NM30 0
X31 NM31 SL2 WL15 BCTM
Vtest31 BL2 NM31 0
X32 NM32 SL2 WL16 BCTM
Vtest32 BL2 NM32 0
X33 NM33 SL3 WL1 BCTM
Vtest33 BL3 NM33 0
X34 NM34 SL3 WL2 BCTM
Vtest34 BL3 NM34 0
X35 NM35 SL3 WL3 BCTM
Vtest35 BL3 NM35 0
X36 NM36 SL3 WL4 BCTM
Vtest36 BL3 NM36 0
X37 NM37 SL3 WL5 BCTM
Vtest37 BL3 NM37 0
X38 NM38 SL3 WL6 BCTM
Vtest38 BL3 NM38 0
X39 NM39 SL3 WL7 BCTM
Vtest39 BL3 NM39 0
X40 NM40 SL3 WL8 BCTM
Vtest40 BL3 NM40 0
X41 NM41 SL3 WL9 BCTM
Vtest41 BL3 NM41 0
X42 NM42 SL3 WL10 BCTM
Vtest42 BL3 NM42 0
X43 NM43 SL3 WL11 BCTM
Vtest43 BL3 NM43 0
X44 NM44 SL3 WL12 BCTM
Vtest44 BL3 NM44 0
X45 NM45 SL3 WL13 BCTM
Vtest45 BL3 NM45 0
X46 NM46 SL3 WL14 BCTM
Vtest46 BL3 NM46 0
X47 NM47 SL3 WL15 BCTM
Vtest47 BL3 NM47 0
X48 NM48 SL3 WL16 BCTM
Vtest48 BL3 NM48 0
X49 NM49 SL4 WL1 BCTM
Vtest49 BL4 NM49 0
X50 NM50 SL4 WL2 BCTM
Vtest50 BL4 NM50 0
X51 NM51 SL4 WL3 BCTM
Vtest51 BL4 NM51 0
X52 NM52 SL4 WL4 BCTM
Vtest52 BL4 NM52 0
X53 NM53 SL4 WL5 BCTM
Vtest53 BL4 NM53 0
X54 NM54 SL4 WL6 BCTM
Vtest54 BL4 NM54 0
X55 NM55 SL4 WL7 BCTM
Vtest55 BL4 NM55 0
X56 NM56 SL4 WL8 BCTM
Vtest56 BL4 NM56 0
X57 NM57 SL4 WL9 BCTM
Vtest57 BL4 NM57 0
X58 NM58 SL4 WL10 BCTM
Vtest58 BL4 NM58 0
X59 NM59 SL4 WL11 BCTM
Vtest59 BL4 NM59 0
X60 NM60 SL4 WL12 BCTM
Vtest60 BL4 NM60 0
X61 NM61 SL4 WL13 BCTM
Vtest61 BL4 NM61 0
X62 NM62 SL4 WL14 BCTM
Vtest62 BL4 NM62 0
X63 NM63 SL4 WL15 BCTM
Vtest63 BL4 NM63 0
X64 NM64 SL4 WL16 BCTM
Vtest64 BL4 NM64 0
X65 NM65 SL5 WL1 BCTM
Vtest65 BL5 NM65 0
X66 NM66 SL5 WL2 BCTM
Vtest66 BL5 NM66 0
X67 NM67 SL5 WL3 BCTM
Vtest67 BL5 NM67 0
X68 NM68 SL5 WL4 BCTM
Vtest68 BL5 NM68 0
X69 NM69 SL5 WL5 BCTM
Vtest69 BL5 NM69 0
X70 NM70 SL5 WL6 BCTM
Vtest70 BL5 NM70 0
X71 NM71 SL5 WL7 BCTM
Vtest71 BL5 NM71 0
X72 NM72 SL5 WL8 BCTM
Vtest72 BL5 NM72 0
X73 NM73 SL5 WL9 BCTM
Vtest73 BL5 NM73 0
X74 NM74 SL5 WL10 BCTM
Vtest74 BL5 NM74 0
X75 NM75 SL5 WL11 BCTM
Vtest75 BL5 NM75 0
X76 NM76 SL5 WL12 BCTM
Vtest76 BL5 NM76 0
X77 NM77 SL5 WL13 BCTM
Vtest77 BL5 NM77 0
X78 NM78 SL5 WL14 BCTM
Vtest78 BL5 NM78 0
X79 NM79 SL5 WL15 BCTM
Vtest79 BL5 NM79 0
X80 NM80 SL5 WL16 BCTM
Vtest80 BL5 NM80 0
X81 NM81 SL6 WL1 BCTM
Vtest81 BL6 NM81 0
X82 NM82 SL6 WL2 BCTM
Vtest82 BL6 NM82 0
X83 NM83 SL6 WL3 BCTM
Vtest83 BL6 NM83 0
X84 NM84 SL6 WL4 BCTM
Vtest84 BL6 NM84 0
X85 NM85 SL6 WL5 BCTM
Vtest85 BL6 NM85 0
X86 NM86 SL6 WL6 BCTM
Vtest86 BL6 NM86 0
X87 NM87 SL6 WL7 BCTM
Vtest87 BL6 NM87 0
X88 NM88 SL6 WL8 BCTM
Vtest88 BL6 NM88 0
X89 NM89 SL6 WL9 BCTM
Vtest89 BL6 NM89 0
X90 NM90 SL6 WL10 BCTM
Vtest90 BL6 NM90 0
X91 NM91 SL6 WL11 BCTM
Vtest91 BL6 NM91 0
X92 NM92 SL6 WL12 BCTM
Vtest92 BL6 NM92 0
X93 NM93 SL6 WL13 BCTM
Vtest93 BL6 NM93 0
X94 NM94 SL6 WL14 BCTM
Vtest94 BL6 NM94 0
X95 NM95 SL6 WL15 BCTM
Vtest95 BL6 NM95 0
X96 NM96 SL6 WL16 BCTM
Vtest96 BL6 NM96 0
X97 NM97 SL7 WL1 BCTM
Vtest97 BL7 NM97 0
X98 NM98 SL7 WL2 BCTM
Vtest98 BL7 NM98 0
X99 NM99 SL7 WL3 BCTM
Vtest99 BL7 NM99 0
X100 NM100 SL7 WL4 BCTM
Vtest100 BL7 NM100 0
X101 NM101 SL7 WL5 BCTM
Vtest101 BL7 NM101 0
X102 NM102 SL7 WL6 BCTM
Vtest102 BL7 NM102 0
X103 NM103 SL7 WL7 BCTM
Vtest103 BL7 NM103 0
X104 NM104 SL7 WL8 BCTM
Vtest104 BL7 NM104 0
X105 NM105 SL7 WL9 BCTM
Vtest105 BL7 NM105 0
X106 NM106 SL7 WL10 BCTM
Vtest106 BL7 NM106 0
X107 NM107 SL7 WL11 BCTM
Vtest107 BL7 NM107 0
X108 NM108 SL7 WL12 BCTM
Vtest108 BL7 NM108 0
X109 NM109 SL7 WL13 BCTM
Vtest109 BL7 NM109 0
X110 NM110 SL7 WL14 BCTM
Vtest110 BL7 NM110 0
X111 NM111 SL7 WL15 BCTM
Vtest111 BL7 NM111 0
X112 NM112 SL7 WL16 BCTM
Vtest112 BL7 NM112 0
X113 NM113 SL8 WL1 BCTM
Vtest113 BL8 NM113 0
X114 NM114 SL8 WL2 BCTM
Vtest114 BL8 NM114 0
X115 NM115 SL8 WL3 BCTM
Vtest115 BL8 NM115 0
X116 NM116 SL8 WL4 BCTM
Vtest116 BL8 NM116 0
X117 NM117 SL8 WL5 BCTM
Vtest117 BL8 NM117 0
X118 NM118 SL8 WL6 BCTM
Vtest118 BL8 NM118 0
X119 NM119 SL8 WL7 BCTM
Vtest119 BL8 NM119 0
X120 NM120 SL8 WL8 BCTM
Vtest120 BL8 NM120 0
X121 NM121 SL8 WL9 BCTM
Vtest121 BL8 NM121 0
X122 NM122 SL8 WL10 BCTM
Vtest122 BL8 NM122 0
X123 NM123 SL8 WL11 BCTM
Vtest123 BL8 NM123 0
X124 NM124 SL8 WL12 BCTM
Vtest124 BL8 NM124 0
X125 NM125 SL8 WL13 BCTM
Vtest125 BL8 NM125 0
X126 NM126 SL8 WL14 BCTM
Vtest126 BL8 NM126 0
X127 NM127 SL8 WL15 BCTM
Vtest127 BL8 NM127 0
X128 NM128 SL8 WL16 BCTM
Vtest128 BL8 NM128 0

* Bitlines Capacitance

Cbl1 BL1 Gnd 'cap'
Cbl2 BL2 Gnd 'cap'
Cbl3 BL3 Gnd 'cap'
Cbl4 BL4 Gnd 'cap'
Cbl5 BL5 Gnd 'cap'
Cbl6 BL6 Gnd 'cap'
Cbl7 BL7 Gnd 'cap'
Cbl8 BL8 Gnd 'cap'

.TRAN 1p 10n

.option rawfmt="psfbin"
