* Crossbar one bit

simulator lang=spice

.include '45nm_LP.pm'
.include 'TRANSGATE.spi'
.include '1T1MBitCell.spi'

.param cap = 1.5f

.param Vvdd = 1.6

.param Vgnd = 0

.param Vread = 0.8

.param TpWord = 0.5n
.param TpWrite = 0.9n
.param TpRead = 0.1n
.param TpPulse = 1n

Vwl1 WL1T Gnd PWL 0 'Vvdd'
Vwl2 WL2T Gnd PWL 0 'Vvdd'
Vwl3 WL3T Gnd PWL 0 'Vvdd'
Vwl4 WL4T Gnd PWL 0 'Vvdd'
Vwl5 WL5T Gnd PWL 0 'Vvdd'
Vwl6 WL6T Gnd PWL 0 'Vvdd'
Vwl7 WL7T Gnd PWL 0 'Vvdd'
Vwl8 WL8T Gnd PWL 0 'Vvdd'
Vwl9 WL9T Gnd PWL 0 'Vvdd'
Vwl10 WL10T Gnd PWL 0 'Vvdd'
Vwl11 WL11T Gnd PWL 0 'Vvdd'
Vwl12 WL12T Gnd PWL 0 'Vvdd'
Vwl13 WL13T Gnd PWL 0 'Vvdd'
Vwl14 WL14T Gnd PWL 0 'Vvdd'
Vwl15 WL15T Gnd PWL 0 'Vvdd'
Vwl16 WL16T Gnd PWL 0 'Vgnd' 'TpPulse-1p' 'Vgnd' 'TpPulse' 'Vvdd' '5n' 'Vvdd' '5n+1p' 'Vgnd'
Vwl17 WL17T Gnd PWL 0 'Vvdd'
Vwl18 WL18T Gnd PWL 0 'Vvdd'
Vwl19 WL19T Gnd PWL 0 'Vvdd'
Vwl20 WL20T Gnd PWL 0 'Vvdd'
Vwl21 WL21T Gnd PWL 0 'Vvdd'
Vwl22 WL22T Gnd PWL 0 'Vvdd'
Vwl23 WL23T Gnd PWL 0 'Vvdd'
Vwl24 WL24T Gnd PWL 0 'Vvdd'
Vwl25 WL25T Gnd PWL 0 'Vvdd'
Vwl26 WL26T Gnd PWL 0 'Vvdd'
Vwl27 WL27T Gnd PWL 0 'Vvdd'
Vwl28 WL28T Gnd PWL 0 'Vvdd'
Vwl29 WL29T Gnd PWL 0 'Vvdd'
Vwl30 WL30T Gnd PWL 0 'Vvdd'
Vwl31 WL31T Gnd PWL 0 'Vvdd'
Vwl32 WL32T Gnd PWL 0 'Vvdd'

Vbl1 BL1T Gnd PWL 0 'Vgnd'
Vbl2 BL2T Gnd PWL 0 'Vgnd'
Vbl3 BL3T Gnd PWL 0 'Vgnd'
Vbl4 BL4T Gnd PWL 0 'Vgnd' '5n+TpWrite-1p' 'Vgnd' '5n+TpWrite' 'Vvdd' '7n-1p' 'Vvdd' '7n' 'Vgnd'
Vbl5 BL5T Gnd PWL 0 'Vgnd'
Vbl6 BL6T Gnd PWL 0 'Vgnd'
Vbl7 BL7T Gnd PWL 0 'Vgnd'
Vbl8 BL8T Gnd PWL 0 'Vgnd'

Vsl1 SL1T Gnd PWL 0 'Vgnd'
Vsl2 SL2T Gnd PWL 0 'Vgnd'
Vsl3 SL3T Gnd PWL 0 'Vgnd'
Vsl4 SL4T Gnd PWL 0 'Vgnd' 'TpRead-1p' 'Vgnd' 'TpRead' 'Vvdd' 'TpRead+TpPulse' 'Vvdd' 'TpRead+TpPulse+1p' 'Vgnd' '8n-1p+TpRead' 'Vgnd' '8n+TpRead' 'Vread' '8n+0.8n' 'Vread' '8n+0.8n+1p' 'Vgnd'
Vsl5 SL5T Gnd PWL 0 'Vgnd'
Vsl6 SL6T Gnd PWL 0 'Vgnd'
Vsl7 SL7T Gnd PWL 0 'Vgnd'
Vsl8 SL8T Gnd PWL 0 'Vgnd'

Vbl1en ENBl1 Gnd PWL 0 'Vgnd'
Vbl2en ENBl2 Gnd PWL 0 'Vgnd'
Vbl3en ENBl3 Gnd PWL 0 'Vgnd'
Vbl4en ENBl4 Gnd PWL 0 'Vvdd'
Vbl5en ENBl5 Gnd PWL 0 'Vgnd'
Vbl6en ENBl6 Gnd PWL 0 'Vgnd'
Vbl7en ENBl7 Gnd PWL 0 'Vgnd'
Vbl8en ENBl8 Gnd PWL 0 'Vgnd'

Vwlen ENWl Gnd PWL 0 'Vgnd'
Vwlen1 ENWl1 Gnd PWL 0 'Vvdd'

Vvdd Vdd Gnd 'Vvdd'

* tristates

X514 WL1T WL1 ENWl Vdd Gnd TG
X515 WL2T WL2 ENWl Vdd Gnd TG
X516 WL3T WL3 ENWl Vdd Gnd TG
X517 WL4T WL4 ENWl Vdd Gnd TG
X518 WL5T WL5 ENWl Vdd Gnd TG
X519 WL6T WL6 ENWl Vdd Gnd TG
X520 WL7T WL7 ENWl Vdd Gnd TG
X521 WL8T WL8 ENWl Vdd Gnd TG
X522 WL9T WL9 ENWl Vdd Gnd TG
X523 WL10T WL10 ENWl Vdd Gnd TG
X524 WL11T WL11 ENWl Vdd Gnd TG
X525 WL12T WL12 ENWl Vdd Gnd TG
X526 WL13T WL13 ENWl Vdd Gnd TG
X527 WL14T WL14 ENWl Vdd Gnd TG
X528 WL15T WL15 ENWl Vdd Gnd TG
X529 WL16T WL16 ENWl1 Vdd Gnd TG
X530 WL17T WL17 ENWl Vdd Gnd TG
X531 WL18T WL18 ENWl Vdd Gnd TG
X532 WL19T WL19 ENWl Vdd Gnd TG
X533 WL20T WL20 ENWl Vdd Gnd TG
X534 WL21T WL21 ENWl Vdd Gnd TG
X535 WL22T WL22 ENWl Vdd Gnd TG
X536 WL23T WL23 ENWl Vdd Gnd TG
X537 WL24T WL24 ENWl Vdd Gnd TG
X538 WL25T WL25 ENWl Vdd Gnd TG
X539 WL26T WL26 ENWl Vdd Gnd TG
X540 WL27T WL27 ENWl Vdd Gnd TG
X541 WL28T WL28 ENWl Vdd Gnd TG
X542 WL29T WL29 ENWl Vdd Gnd TG
X543 WL30T WL30 ENWl Vdd Gnd TG
X544 WL31T WL31 ENWl Vdd Gnd TG
X545 WL32T WL32 ENWl Vdd Gnd TG

X599 BL1T BL1 ENBl1 Vdd Gnd TG
X590 BL2T BL2 ENBl2 Vdd Gnd TG
X591 BL3T BL3 ENBl3 Vdd Gnd TG
X592 BL4T BL4 ENBl4 Vdd Gnd TG
X593 BL5T BL5 ENBl5 Vdd Gnd TG
X594 BL6T BL6 ENBl6 Vdd Gnd TG
X595 BL7T BL7 ENBl7 Vdd Gnd TG
X596 BL8T BL8 ENBl8 Vdd Gnd TG

X679 SL1T SL1 ENBl1 Vdd Gnd TG
X680 SL2T SL2 ENBl2 Vdd Gnd TG
X681 SL3T SL3 ENBl3 Vdd Gnd TG
X682 SL4T SL4 ENBl4 Vdd Gnd TG
X683 SL5T SL5 ENBl5 Vdd Gnd TG
X684 SL6T SL6 ENBl6 Vdd Gnd TG
X685 SL7T SL7 ENBl7 Vdd Gnd TG
X686 SL8T SL8 ENBl8 Vdd Gnd TG

* Bitcell

X1 NM1 SL1 WL1 BCTM
Vtest1 BL1 NM1 0
X2 NM2 SL1 WL2 BCTM
Vtest2 BL1 NM2 0
X3 NM3 SL1 WL3 BCTM
Vtest3 BL1 NM3 0
X4 NM4 SL1 WL4 BCTM
Vtest4 BL1 NM4 0
X5 NM5 SL1 WL5 BCTM
Vtest5 BL1 NM5 0
X6 NM6 SL1 WL6 BCTM
Vtest6 BL1 NM6 0
X7 NM7 SL1 WL7 BCTM
Vtest7 BL1 NM7 0
X8 NM8 SL1 WL8 BCTM
Vtest8 BL1 NM8 0
X9 NM9 SL1 WL9 BCTM
Vtest9 BL1 NM9 0
X10 NM10 SL1 WL10 BCTM
Vtest10 BL1 NM10 0
X11 NM11 SL1 WL11 BCTM
Vtest11 BL1 NM11 0
X12 NM12 SL1 WL12 BCTM
Vtest12 BL1 NM12 0
X13 NM13 SL1 WL13 BCTM
Vtest13 BL1 NM13 0
X14 NM14 SL1 WL14 BCTM
Vtest14 BL1 NM14 0
X15 NM15 SL1 WL15 BCTM
Vtest15 BL1 NM15 0
X16 NM16 SL1 WL16 BCTM
Vtest16 BL1 NM16 0
X17 NM17 SL1 WL17 BCTM
Vtest17 BL1 NM17 0
X18 NM18 SL1 WL18 BCTM
Vtest18 BL1 NM18 0
X19 NM19 SL1 WL19 BCTM
Vtest19 BL1 NM19 0
X20 NM20 SL1 WL20 BCTM
Vtest20 BL1 NM20 0
X21 NM21 SL1 WL21 BCTM
Vtest21 BL1 NM21 0
X22 NM22 SL1 WL22 BCTM
Vtest22 BL1 NM22 0
X23 NM23 SL1 WL23 BCTM
Vtest23 BL1 NM23 0
X24 NM24 SL1 WL24 BCTM
Vtest24 BL1 NM24 0
X25 NM25 SL1 WL25 BCTM
Vtest25 BL1 NM25 0
X26 NM26 SL1 WL26 BCTM
Vtest26 BL1 NM26 0
X27 NM27 SL1 WL27 BCTM
Vtest27 BL1 NM27 0
X28 NM28 SL1 WL28 BCTM
Vtest28 BL1 NM28 0
X29 NM29 SL1 WL29 BCTM
Vtest29 BL1 NM29 0
X30 NM30 SL1 WL30 BCTM
Vtest30 BL1 NM30 0
X31 NM31 SL1 WL31 BCTM
Vtest31 BL1 NM31 0
X32 NM32 SL1 WL32 BCTM
Vtest32 BL1 NM32 0
X33 NM33 SL2 WL1 BCTM
Vtest33 BL2 NM33 0
X34 NM34 SL2 WL2 BCTM
Vtest34 BL2 NM34 0
X35 NM35 SL2 WL3 BCTM
Vtest35 BL2 NM35 0
X36 NM36 SL2 WL4 BCTM
Vtest36 BL2 NM36 0
X37 NM37 SL2 WL5 BCTM
Vtest37 BL2 NM37 0
X38 NM38 SL2 WL6 BCTM
Vtest38 BL2 NM38 0
X39 NM39 SL2 WL7 BCTM
Vtest39 BL2 NM39 0
X40 NM40 SL2 WL8 BCTM
Vtest40 BL2 NM40 0
X41 NM41 SL2 WL9 BCTM
Vtest41 BL2 NM41 0
X42 NM42 SL2 WL10 BCTM
Vtest42 BL2 NM42 0
X43 NM43 SL2 WL11 BCTM
Vtest43 BL2 NM43 0
X44 NM44 SL2 WL12 BCTM
Vtest44 BL2 NM44 0
X45 NM45 SL2 WL13 BCTM
Vtest45 BL2 NM45 0
X46 NM46 SL2 WL14 BCTM
Vtest46 BL2 NM46 0
X47 NM47 SL2 WL15 BCTM
Vtest47 BL2 NM47 0
X48 NM48 SL2 WL16 BCTM
Vtest48 BL2 NM48 0
X49 NM49 SL2 WL17 BCTM
Vtest49 BL2 NM49 0
X50 NM50 SL2 WL18 BCTM
Vtest50 BL2 NM50 0
X51 NM51 SL2 WL19 BCTM
Vtest51 BL2 NM51 0
X52 NM52 SL2 WL20 BCTM
Vtest52 BL2 NM52 0
X53 NM53 SL2 WL21 BCTM
Vtest53 BL2 NM53 0
X54 NM54 SL2 WL22 BCTM
Vtest54 BL2 NM54 0
X55 NM55 SL2 WL23 BCTM
Vtest55 BL2 NM55 0
X56 NM56 SL2 WL24 BCTM
Vtest56 BL2 NM56 0
X57 NM57 SL2 WL25 BCTM
Vtest57 BL2 NM57 0
X58 NM58 SL2 WL26 BCTM
Vtest58 BL2 NM58 0
X59 NM59 SL2 WL27 BCTM
Vtest59 BL2 NM59 0
X60 NM60 SL2 WL28 BCTM
Vtest60 BL2 NM60 0
X61 NM61 SL2 WL29 BCTM
Vtest61 BL2 NM61 0
X62 NM62 SL2 WL30 BCTM
Vtest62 BL2 NM62 0
X63 NM63 SL2 WL31 BCTM
Vtest63 BL2 NM63 0
X64 NM64 SL2 WL32 BCTM
Vtest64 BL2 NM64 0
X65 NM65 SL3 WL1 BCTM
Vtest65 BL3 NM65 0
X66 NM66 SL3 WL2 BCTM
Vtest66 BL3 NM66 0
X67 NM67 SL3 WL3 BCTM
Vtest67 BL3 NM67 0
X68 NM68 SL3 WL4 BCTM
Vtest68 BL3 NM68 0
X69 NM69 SL3 WL5 BCTM
Vtest69 BL3 NM69 0
X70 NM70 SL3 WL6 BCTM
Vtest70 BL3 NM70 0
X71 NM71 SL3 WL7 BCTM
Vtest71 BL3 NM71 0
X72 NM72 SL3 WL8 BCTM
Vtest72 BL3 NM72 0
X73 NM73 SL3 WL9 BCTM
Vtest73 BL3 NM73 0
X74 NM74 SL3 WL10 BCTM
Vtest74 BL3 NM74 0
X75 NM75 SL3 WL11 BCTM
Vtest75 BL3 NM75 0
X76 NM76 SL3 WL12 BCTM
Vtest76 BL3 NM76 0
X77 NM77 SL3 WL13 BCTM
Vtest77 BL3 NM77 0
X78 NM78 SL3 WL14 BCTM
Vtest78 BL3 NM78 0
X79 NM79 SL3 WL15 BCTM
Vtest79 BL3 NM79 0
X80 NM80 SL3 WL16 BCTM
Vtest80 BL3 NM80 0
X81 NM81 SL3 WL17 BCTM
Vtest81 BL3 NM81 0
X82 NM82 SL3 WL18 BCTM
Vtest82 BL3 NM82 0
X83 NM83 SL3 WL19 BCTM
Vtest83 BL3 NM83 0
X84 NM84 SL3 WL20 BCTM
Vtest84 BL3 NM84 0
X85 NM85 SL3 WL21 BCTM
Vtest85 BL3 NM85 0
X86 NM86 SL3 WL22 BCTM
Vtest86 BL3 NM86 0
X87 NM87 SL3 WL23 BCTM
Vtest87 BL3 NM87 0
X88 NM88 SL3 WL24 BCTM
Vtest88 BL3 NM88 0
X89 NM89 SL3 WL25 BCTM
Vtest89 BL3 NM89 0
X90 NM90 SL3 WL26 BCTM
Vtest90 BL3 NM90 0
X91 NM91 SL3 WL27 BCTM
Vtest91 BL3 NM91 0
X92 NM92 SL3 WL28 BCTM
Vtest92 BL3 NM92 0
X93 NM93 SL3 WL29 BCTM
Vtest93 BL3 NM93 0
X94 NM94 SL3 WL30 BCTM
Vtest94 BL3 NM94 0
X95 NM95 SL3 WL31 BCTM
Vtest95 BL3 NM95 0
X96 NM96 SL3 WL32 BCTM
Vtest96 BL3 NM96 0
X97 NM97 SL4 WL1 BCTM
Vtest97 BL4 NM97 0
X98 NM98 SL4 WL2 BCTM
Vtest98 BL4 NM98 0
X99 NM99 SL4 WL3 BCTM
Vtest99 BL4 NM99 0
X100 NM100 SL4 WL4 BCTM
Vtest100 BL4 NM100 0
X101 NM101 SL4 WL5 BCTM
Vtest101 BL4 NM101 0
X102 NM102 SL4 WL6 BCTM
Vtest102 BL4 NM102 0
X103 NM103 SL4 WL7 BCTM
Vtest103 BL4 NM103 0
X104 NM104 SL4 WL8 BCTM
Vtest104 BL4 NM104 0
X105 NM105 SL4 WL9 BCTM
Vtest105 BL4 NM105 0
X106 NM106 SL4 WL10 BCTM
Vtest106 BL4 NM106 0
X107 NM107 SL4 WL11 BCTM
Vtest107 BL4 NM107 0
X108 NM108 SL4 WL12 BCTM
Vtest108 BL4 NM108 0
X109 NM109 SL4 WL13 BCTM
Vtest109 BL4 NM109 0
X110 NM110 SL4 WL14 BCTM
Vtest110 BL4 NM110 0
X111 NM111 SL4 WL15 BCTM
Vtest111 BL4 NM111 0
X112 NM112 SL4 WL16 BCTM
Vtest112 BL4 NM112 0
X113 NM113 SL4 WL17 BCTM
Vtest113 BL4 NM113 0
X114 NM114 SL4 WL18 BCTM
Vtest114 BL4 NM114 0
X115 NM115 SL4 WL19 BCTM
Vtest115 BL4 NM115 0
X116 NM116 SL4 WL20 BCTM
Vtest116 BL4 NM116 0
X117 NM117 SL4 WL21 BCTM
Vtest117 BL4 NM117 0
X118 NM118 SL4 WL22 BCTM
Vtest118 BL4 NM118 0
X119 NM119 SL4 WL23 BCTM
Vtest119 BL4 NM119 0
X120 NM120 SL4 WL24 BCTM
Vtest120 BL4 NM120 0
X121 NM121 SL4 WL25 BCTM
Vtest121 BL4 NM121 0
X122 NM122 SL4 WL26 BCTM
Vtest122 BL4 NM122 0
X123 NM123 SL4 WL27 BCTM
Vtest123 BL4 NM123 0
X124 NM124 SL4 WL28 BCTM
Vtest124 BL4 NM124 0
X125 NM125 SL4 WL29 BCTM
Vtest125 BL4 NM125 0
X126 NM126 SL4 WL30 BCTM
Vtest126 BL4 NM126 0
X127 NM127 SL4 WL31 BCTM
Vtest127 BL4 NM127 0
X128 NM128 SL4 WL32 BCTM
Vtest128 BL4 NM128 0
X129 NM129 SL5 WL1 BCTM
Vtest129 BL5 NM129 0
X130 NM130 SL5 WL2 BCTM
Vtest130 BL5 NM130 0
X131 NM131 SL5 WL3 BCTM
Vtest131 BL5 NM131 0
X132 NM132 SL5 WL4 BCTM
Vtest132 BL5 NM132 0
X133 NM133 SL5 WL5 BCTM
Vtest133 BL5 NM133 0
X134 NM134 SL5 WL6 BCTM
Vtest134 BL5 NM134 0
X135 NM135 SL5 WL7 BCTM
Vtest135 BL5 NM135 0
X136 NM136 SL5 WL8 BCTM
Vtest136 BL5 NM136 0
X137 NM137 SL5 WL9 BCTM
Vtest137 BL5 NM137 0
X138 NM138 SL5 WL10 BCTM
Vtest138 BL5 NM138 0
X139 NM139 SL5 WL11 BCTM
Vtest139 BL5 NM139 0
X140 NM140 SL5 WL12 BCTM
Vtest140 BL5 NM140 0
X141 NM141 SL5 WL13 BCTM
Vtest141 BL5 NM141 0
X142 NM142 SL5 WL14 BCTM
Vtest142 BL5 NM142 0
X143 NM143 SL5 WL15 BCTM
Vtest143 BL5 NM143 0
X144 NM144 SL5 WL16 BCTM
Vtest144 BL5 NM144 0
X145 NM145 SL5 WL17 BCTM
Vtest145 BL5 NM145 0
X146 NM146 SL5 WL18 BCTM
Vtest146 BL5 NM146 0
X147 NM147 SL5 WL19 BCTM
Vtest147 BL5 NM147 0
X148 NM148 SL5 WL20 BCTM
Vtest148 BL5 NM148 0
X149 NM149 SL5 WL21 BCTM
Vtest149 BL5 NM149 0
X150 NM150 SL5 WL22 BCTM
Vtest150 BL5 NM150 0
X151 NM151 SL5 WL23 BCTM
Vtest151 BL5 NM151 0
X152 NM152 SL5 WL24 BCTM
Vtest152 BL5 NM152 0
X153 NM153 SL5 WL25 BCTM
Vtest153 BL5 NM153 0
X154 NM154 SL5 WL26 BCTM
Vtest154 BL5 NM154 0
X155 NM155 SL5 WL27 BCTM
Vtest155 BL5 NM155 0
X156 NM156 SL5 WL28 BCTM
Vtest156 BL5 NM156 0
X157 NM157 SL5 WL29 BCTM
Vtest157 BL5 NM157 0
X158 NM158 SL5 WL30 BCTM
Vtest158 BL5 NM158 0
X159 NM159 SL5 WL31 BCTM
Vtest159 BL5 NM159 0
X160 NM160 SL5 WL32 BCTM
Vtest160 BL5 NM160 0
X161 NM161 SL6 WL1 BCTM
Vtest161 BL6 NM161 0
X162 NM162 SL6 WL2 BCTM
Vtest162 BL6 NM162 0
X163 NM163 SL6 WL3 BCTM
Vtest163 BL6 NM163 0
X164 NM164 SL6 WL4 BCTM
Vtest164 BL6 NM164 0
X165 NM165 SL6 WL5 BCTM
Vtest165 BL6 NM165 0
X166 NM166 SL6 WL6 BCTM
Vtest166 BL6 NM166 0
X167 NM167 SL6 WL7 BCTM
Vtest167 BL6 NM167 0
X168 NM168 SL6 WL8 BCTM
Vtest168 BL6 NM168 0
X169 NM169 SL6 WL9 BCTM
Vtest169 BL6 NM169 0
X170 NM170 SL6 WL10 BCTM
Vtest170 BL6 NM170 0
X171 NM171 SL6 WL11 BCTM
Vtest171 BL6 NM171 0
X172 NM172 SL6 WL12 BCTM
Vtest172 BL6 NM172 0
X173 NM173 SL6 WL13 BCTM
Vtest173 BL6 NM173 0
X174 NM174 SL6 WL14 BCTM
Vtest174 BL6 NM174 0
X175 NM175 SL6 WL15 BCTM
Vtest175 BL6 NM175 0
X176 NM176 SL6 WL16 BCTM
Vtest176 BL6 NM176 0
X177 NM177 SL6 WL17 BCTM
Vtest177 BL6 NM177 0
X178 NM178 SL6 WL18 BCTM
Vtest178 BL6 NM178 0
X179 NM179 SL6 WL19 BCTM
Vtest179 BL6 NM179 0
X180 NM180 SL6 WL20 BCTM
Vtest180 BL6 NM180 0
X181 NM181 SL6 WL21 BCTM
Vtest181 BL6 NM181 0
X182 NM182 SL6 WL22 BCTM
Vtest182 BL6 NM182 0
X183 NM183 SL6 WL23 BCTM
Vtest183 BL6 NM183 0
X184 NM184 SL6 WL24 BCTM
Vtest184 BL6 NM184 0
X185 NM185 SL6 WL25 BCTM
Vtest185 BL6 NM185 0
X186 NM186 SL6 WL26 BCTM
Vtest186 BL6 NM186 0
X187 NM187 SL6 WL27 BCTM
Vtest187 BL6 NM187 0
X188 NM188 SL6 WL28 BCTM
Vtest188 BL6 NM188 0
X189 NM189 SL6 WL29 BCTM
Vtest189 BL6 NM189 0
X190 NM190 SL6 WL30 BCTM
Vtest190 BL6 NM190 0
X191 NM191 SL6 WL31 BCTM
Vtest191 BL6 NM191 0
X192 NM192 SL6 WL32 BCTM
Vtest192 BL6 NM192 0
X193 NM193 SL7 WL1 BCTM
Vtest193 BL7 NM193 0
X194 NM194 SL7 WL2 BCTM
Vtest194 BL7 NM194 0
X195 NM195 SL7 WL3 BCTM
Vtest195 BL7 NM195 0
X196 NM196 SL7 WL4 BCTM
Vtest196 BL7 NM196 0
X197 NM197 SL7 WL5 BCTM
Vtest197 BL7 NM197 0
X198 NM198 SL7 WL6 BCTM
Vtest198 BL7 NM198 0
X199 NM199 SL7 WL7 BCTM
Vtest199 BL7 NM199 0
X200 NM200 SL7 WL8 BCTM
Vtest200 BL7 NM200 0
X201 NM201 SL7 WL9 BCTM
Vtest201 BL7 NM201 0
X202 NM202 SL7 WL10 BCTM
Vtest202 BL7 NM202 0
X203 NM203 SL7 WL11 BCTM
Vtest203 BL7 NM203 0
X204 NM204 SL7 WL12 BCTM
Vtest204 BL7 NM204 0
X205 NM205 SL7 WL13 BCTM
Vtest205 BL7 NM205 0
X206 NM206 SL7 WL14 BCTM
Vtest206 BL7 NM206 0
X207 NM207 SL7 WL15 BCTM
Vtest207 BL7 NM207 0
X208 NM208 SL7 WL16 BCTM
Vtest208 BL7 NM208 0
X209 NM209 SL7 WL17 BCTM
Vtest209 BL7 NM209 0
X210 NM210 SL7 WL18 BCTM
Vtest210 BL7 NM210 0
X211 NM211 SL7 WL19 BCTM
Vtest211 BL7 NM211 0
X212 NM212 SL7 WL20 BCTM
Vtest212 BL7 NM212 0
X213 NM213 SL7 WL21 BCTM
Vtest213 BL7 NM213 0
X214 NM214 SL7 WL22 BCTM
Vtest214 BL7 NM214 0
X215 NM215 SL7 WL23 BCTM
Vtest215 BL7 NM215 0
X216 NM216 SL7 WL24 BCTM
Vtest216 BL7 NM216 0
X217 NM217 SL7 WL25 BCTM
Vtest217 BL7 NM217 0
X218 NM218 SL7 WL26 BCTM
Vtest218 BL7 NM218 0
X219 NM219 SL7 WL27 BCTM
Vtest219 BL7 NM219 0
X220 NM220 SL7 WL28 BCTM
Vtest220 BL7 NM220 0
X221 NM221 SL7 WL29 BCTM
Vtest221 BL7 NM221 0
X222 NM222 SL7 WL30 BCTM
Vtest222 BL7 NM222 0
X223 NM223 SL7 WL31 BCTM
Vtest223 BL7 NM223 0
X224 NM224 SL7 WL32 BCTM
Vtest224 BL7 NM224 0
X225 NM225 SL8 WL1 BCTM
Vtest225 BL8 NM225 0
X226 NM226 SL8 WL2 BCTM
Vtest226 BL8 NM226 0
X227 NM227 SL8 WL3 BCTM
Vtest227 BL8 NM227 0
X228 NM228 SL8 WL4 BCTM
Vtest228 BL8 NM228 0
X229 NM229 SL8 WL5 BCTM
Vtest229 BL8 NM229 0
X230 NM230 SL8 WL6 BCTM
Vtest230 BL8 NM230 0
X231 NM231 SL8 WL7 BCTM
Vtest231 BL8 NM231 0
X232 NM232 SL8 WL8 BCTM
Vtest232 BL8 NM232 0
X233 NM233 SL8 WL9 BCTM
Vtest233 BL8 NM233 0
X234 NM234 SL8 WL10 BCTM
Vtest234 BL8 NM234 0
X235 NM235 SL8 WL11 BCTM
Vtest235 BL8 NM235 0
X236 NM236 SL8 WL12 BCTM
Vtest236 BL8 NM236 0
X237 NM237 SL8 WL13 BCTM
Vtest237 BL8 NM237 0
X238 NM238 SL8 WL14 BCTM
Vtest238 BL8 NM238 0
X239 NM239 SL8 WL15 BCTM
Vtest239 BL8 NM239 0
X240 NM240 SL8 WL16 BCTM
Vtest240 BL8 NM240 0
X241 NM241 SL8 WL17 BCTM
Vtest241 BL8 NM241 0
X242 NM242 SL8 WL18 BCTM
Vtest242 BL8 NM242 0
X243 NM243 SL8 WL19 BCTM
Vtest243 BL8 NM243 0
X244 NM244 SL8 WL20 BCTM
Vtest244 BL8 NM244 0
X245 NM245 SL8 WL21 BCTM
Vtest245 BL8 NM245 0
X246 NM246 SL8 WL22 BCTM
Vtest246 BL8 NM246 0
X247 NM247 SL8 WL23 BCTM
Vtest247 BL8 NM247 0
X248 NM248 SL8 WL24 BCTM
Vtest248 BL8 NM248 0
X249 NM249 SL8 WL25 BCTM
Vtest249 BL8 NM249 0
X250 NM250 SL8 WL26 BCTM
Vtest250 BL8 NM250 0
X251 NM251 SL8 WL27 BCTM
Vtest251 BL8 NM251 0
X252 NM252 SL8 WL28 BCTM
Vtest252 BL8 NM252 0
X253 NM253 SL8 WL29 BCTM
Vtest253 BL8 NM253 0
X254 NM254 SL8 WL30 BCTM
Vtest254 BL8 NM254 0
X255 NM255 SL8 WL31 BCTM
Vtest255 BL8 NM255 0
X256 NM256 SL8 WL32 BCTM
Vtest256 BL8 NM256 0

* Bitlines Capacitance

Cbl1 BL1 Gnd 'cap'
Cbl2 BL2 Gnd 'cap'
Cbl3 BL3 Gnd 'cap'
Cbl4 BL4 Gnd 'cap'
Cbl5 BL5 Gnd 'cap'
Cbl6 BL6 Gnd 'cap'
Cbl7 BL7 Gnd 'cap'
Cbl8 BL8 Gnd 'cap'

.TRAN 1p 10n

.option rawfmt="psfbin"
