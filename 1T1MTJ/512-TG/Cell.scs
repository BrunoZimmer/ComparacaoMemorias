* Crossbar one bit

simulator lang=spice

.include '45nm_LP.pm'
.include 'TRANSGATE.spi'
.include '1T1MBitCell.spi'

.param cap = 1.5f

.param Vvdd = 1.6

.param Vgnd = 0

.param Vread = 0.8

.param TpWord = 0.5n
.param TpWrite = 0.9n
.param TpRead = 0.1n
.param TpPulse = 1n

Vwl1 WL1T Gnd PWL 0 'Vgnd'
Vwl2 WL2T Gnd PWL 0 'Vgnd'
Vwl3 WL3T Gnd PWL 0 'Vgnd'
Vwl4 WL4T Gnd PWL 0 'Vgnd'
Vwl5 WL5T Gnd PWL 0 'Vgnd'
Vwl6 WL6T Gnd PWL 0 'Vgnd'
Vwl7 WL7T Gnd PWL 0 'Vgnd'
Vwl8 WL8T Gnd PWL 0 'Vgnd'
Vwl9 WL9T Gnd PWL 0 'Vgnd'
Vwl10 WL10T Gnd PWL 0 'Vgnd'
Vwl11 WL11T Gnd PWL 0 'Vgnd'
Vwl12 WL12T Gnd PWL 0 'Vgnd'
Vwl13 WL13T Gnd PWL 0 'Vgnd'
Vwl14 WL14T Gnd PWL 0 'Vgnd'
Vwl15 WL15T Gnd PWL 0 'Vgnd'
Vwl16 WL16T Gnd PWL 0 'Vgnd'
Vwl17 WL17T Gnd PWL 0 'Vgnd'
Vwl18 WL18T Gnd PWL 0 'Vgnd'
Vwl19 WL19T Gnd PWL 0 'Vgnd'
Vwl20 WL20T Gnd PWL 0 'Vgnd'
Vwl21 WL21T Gnd PWL 0 'Vgnd'
Vwl22 WL22T Gnd PWL 0 'Vgnd'
Vwl23 WL23T Gnd PWL 0 'Vgnd'
Vwl24 WL24T Gnd PWL 0 'Vgnd'
Vwl25 WL25T Gnd PWL 0 'Vgnd'
Vwl26 WL26T Gnd PWL 0 'Vgnd'
Vwl27 WL27T Gnd PWL 0 'Vgnd'
Vwl28 WL28T Gnd PWL 0 'Vgnd'
Vwl29 WL29T Gnd PWL 0 'Vgnd'
Vwl30 WL30T Gnd PWL 0 'Vgnd'
Vwl31 WL31T Gnd PWL 0 'Vgnd'
Vwl32 WL32T Gnd PWL 0 'Vvdd' 'TpPulse-1p' 'Vvdd' 'TpPulse' 'Vgnd' '5n' 'Vgnd' '5n+1p' 'Vvdd'
Vwl33 WL33T Gnd PWL 0 'Vgnd'
Vwl34 WL34T Gnd PWL 0 'Vgnd'
Vwl35 WL35T Gnd PWL 0 'Vgnd'
Vwl36 WL36T Gnd PWL 0 'Vgnd'
Vwl37 WL37T Gnd PWL 0 'Vgnd'
Vwl38 WL38T Gnd PWL 0 'Vgnd'
Vwl39 WL39T Gnd PWL 0 'Vgnd'
Vwl40 WL40T Gnd PWL 0 'Vgnd'
Vwl41 WL41T Gnd PWL 0 'Vgnd'
Vwl42 WL42T Gnd PWL 0 'Vgnd'
Vwl43 WL43T Gnd PWL 0 'Vgnd'
Vwl44 WL44T Gnd PWL 0 'Vgnd'
Vwl45 WL45T Gnd PWL 0 'Vgnd'
Vwl46 WL46T Gnd PWL 0 'Vgnd'
Vwl47 WL47T Gnd PWL 0 'Vgnd'
Vwl48 WL48T Gnd PWL 0 'Vgnd'
Vwl49 WL49T Gnd PWL 0 'Vgnd'
Vwl50 WL50T Gnd PWL 0 'Vgnd'
Vwl51 WL51T Gnd PWL 0 'Vgnd'
Vwl52 WL52T Gnd PWL 0 'Vgnd'
Vwl53 WL53T Gnd PWL 0 'Vgnd'
Vwl54 WL54T Gnd PWL 0 'Vgnd'
Vwl55 WL55T Gnd PWL 0 'Vgnd'
Vwl56 WL56T Gnd PWL 0 'Vgnd'
Vwl57 WL57T Gnd PWL 0 'Vgnd'
Vwl58 WL58T Gnd PWL 0 'Vgnd'
Vwl59 WL59T Gnd PWL 0 'Vgnd'
Vwl60 WL60T Gnd PWL 0 'Vgnd'
Vwl61 WL61T Gnd PWL 0 'Vgnd'
Vwl62 WL62T Gnd PWL 0 'Vgnd'
Vwl63 WL63T Gnd PWL 0 'Vgnd'
Vwl64 WL64T Gnd PWL 0 'Vgnd'

Vbl1 BL1T Gnd PWL 0 'Vgnd'
Vbl2 BL2T Gnd PWL 0 'Vgnd'
Vbl3 BL3T Gnd PWL 0 'Vgnd'
Vbl4 BL4T Gnd PWL 0 'Vgnd' '5n+TpWrite-1p' 'Vgnd' '5n+TpWrite' 'Vvdd' '7n-1p' 'Vvdd' '7n' 'Vgnd'
Vbl5 BL5T Gnd PWL 0 'Vgnd'
Vbl6 BL6T Gnd PWL 0 'Vgnd'
Vbl7 BL7T Gnd PWL 0 'Vgnd'
Vbl8 BL8T Gnd PWL 0 'Vgnd'

Vsl1 SL1T Gnd PWL 0 'Vgnd'
Vsl2 SL2T Gnd PWL 0 'Vgnd'
Vsl3 SL3T Gnd PWL 0 'Vgnd'
Vsl4 SL4T Gnd PWL 0 'Vgnd' 'TpRead-1p' 'Vgnd' 'TpRead' 'Vvdd' 'TpRead+TpPulse' 'Vvdd' 'TpRead+TpPulse+1p' 'Vgnd' '8n-1p+TpRead' 'Vgnd' '8n+TpRead' 'Vread' '8n+0.8n' 'Vread' '8n+0.8n+1p' 'Vgnd'
Vsl5 SL5T Gnd PWL 0 'Vgnd'
Vsl6 SL6T Gnd PWL 0 'Vgnd'
Vsl7 SL7T Gnd PWL 0 'Vgnd'
Vsl8 SL8T Gnd PWL 0 'Vgnd'

Vbl1en ENBl1 Gnd PWL 0 'Vgnd'
Vbl2en ENBl2 Gnd PWL 0 'Vgnd'
Vbl3en ENBl3 Gnd PWL 0 'Vgnd'
Vbl4en ENBl4 Gnd PWL 0 'Vvdd'
Vbl5en ENBl5 Gnd PWL 0 'Vgnd'
Vbl6en ENBl6 Gnd PWL 0 'Vgnd'
Vbl7en ENBl7 Gnd PWL 0 'Vgnd'
Vbl8en ENBl8 Gnd PWL 0 'Vgnd'

Vwlen ENWl Gnd PWL 0 'Vgnd'
Vwlen1 ENWl1 Gnd PWL 0 'Vvdd'

Vvdd Vdd Gnd 'Vvdd'

* Bitcell

X1 NM1 SL1 WL1 BCTM
Vtest1 BL1 NM1 0
X2 NM2 SL1 WL2 BCTM
Vtest2 BL1 NM2 0
X3 NM3 SL1 WL3 BCTM
Vtest3 BL1 NM3 0
X4 NM4 SL1 WL4 BCTM
Vtest4 BL1 NM4 0
X5 NM5 SL1 WL5 BCTM
Vtest5 BL1 NM5 0
X6 NM6 SL1 WL6 BCTM
Vtest6 BL1 NM6 0
X7 NM7 SL1 WL7 BCTM
Vtest7 BL1 NM7 0
X8 NM8 SL1 WL8 BCTM
Vtest8 BL1 NM8 0
X9 NM9 SL1 WL9 BCTM
Vtest9 BL1 NM9 0
X10 NM10 SL1 WL10 BCTM
Vtest10 BL1 NM10 0
X11 NM11 SL1 WL11 BCTM
Vtest11 BL1 NM11 0
X12 NM12 SL1 WL12 BCTM
Vtest12 BL1 NM12 0
X13 NM13 SL1 WL13 BCTM
Vtest13 BL1 NM13 0
X14 NM14 SL1 WL14 BCTM
Vtest14 BL1 NM14 0
X15 NM15 SL1 WL15 BCTM
Vtest15 BL1 NM15 0
X16 NM16 SL1 WL16 BCTM
Vtest16 BL1 NM16 0
X17 NM17 SL1 WL17 BCTM
Vtest17 BL1 NM17 0
X18 NM18 SL1 WL18 BCTM
Vtest18 BL1 NM18 0
X19 NM19 SL1 WL19 BCTM
Vtest19 BL1 NM19 0
X20 NM20 SL1 WL20 BCTM
Vtest20 BL1 NM20 0
X21 NM21 SL1 WL21 BCTM
Vtest21 BL1 NM21 0
X22 NM22 SL1 WL22 BCTM
Vtest22 BL1 NM22 0
X23 NM23 SL1 WL23 BCTM
Vtest23 BL1 NM23 0
X24 NM24 SL1 WL24 BCTM
Vtest24 BL1 NM24 0
X25 NM25 SL1 WL25 BCTM
Vtest25 BL1 NM25 0
X26 NM26 SL1 WL26 BCTM
Vtest26 BL1 NM26 0
X27 NM27 SL1 WL27 BCTM
Vtest27 BL1 NM27 0
X28 NM28 SL1 WL28 BCTM
Vtest28 BL1 NM28 0
X29 NM29 SL1 WL29 BCTM
Vtest29 BL1 NM29 0
X30 NM30 SL1 WL30 BCTM
Vtest30 BL1 NM30 0
X31 NM31 SL1 WL31 BCTM
Vtest31 BL1 NM31 0
X32 NM32 SL1 WL32 BCTM
Vtest32 BL1 NM32 0
X33 NM33 SL1 WL33 BCTM
Vtest33 BL1 NM33 0
X34 NM34 SL1 WL34 BCTM
Vtest34 BL1 NM34 0
X35 NM35 SL1 WL35 BCTM
Vtest35 BL1 NM35 0
X36 NM36 SL1 WL36 BCTM
Vtest36 BL1 NM36 0
X37 NM37 SL1 WL37 BCTM
Vtest37 BL1 NM37 0
X38 NM38 SL1 WL38 BCTM
Vtest38 BL1 NM38 0
X39 NM39 SL1 WL39 BCTM
Vtest39 BL1 NM39 0
X40 NM40 SL1 WL40 BCTM
Vtest40 BL1 NM40 0
X41 NM41 SL1 WL41 BCTM
Vtest41 BL1 NM41 0
X42 NM42 SL1 WL42 BCTM
Vtest42 BL1 NM42 0
X43 NM43 SL1 WL43 BCTM
Vtest43 BL1 NM43 0
X44 NM44 SL1 WL44 BCTM
Vtest44 BL1 NM44 0
X45 NM45 SL1 WL45 BCTM
Vtest45 BL1 NM45 0
X46 NM46 SL1 WL46 BCTM
Vtest46 BL1 NM46 0
X47 NM47 SL1 WL47 BCTM
Vtest47 BL1 NM47 0
X48 NM48 SL1 WL48 BCTM
Vtest48 BL1 NM48 0
X49 NM49 SL1 WL49 BCTM
Vtest49 BL1 NM49 0
X50 NM50 SL1 WL50 BCTM
Vtest50 BL1 NM50 0
X51 NM51 SL1 WL51 BCTM
Vtest51 BL1 NM51 0
X52 NM52 SL1 WL52 BCTM
Vtest52 BL1 NM52 0
X53 NM53 SL1 WL53 BCTM
Vtest53 BL1 NM53 0
X54 NM54 SL1 WL54 BCTM
Vtest54 BL1 NM54 0
X55 NM55 SL1 WL55 BCTM
Vtest55 BL1 NM55 0
X56 NM56 SL1 WL56 BCTM
Vtest56 BL1 NM56 0
X57 NM57 SL1 WL57 BCTM
Vtest57 BL1 NM57 0
X58 NM58 SL1 WL58 BCTM
Vtest58 BL1 NM58 0
X59 NM59 SL1 WL59 BCTM
Vtest59 BL1 NM59 0
X60 NM60 SL1 WL60 BCTM
Vtest60 BL1 NM60 0
X61 NM61 SL1 WL61 BCTM
Vtest61 BL1 NM61 0
X62 NM62 SL1 WL62 BCTM
Vtest62 BL1 NM62 0
X63 NM63 SL1 WL63 BCTM
Vtest63 BL1 NM63 0
X64 NM64 SL1 WL64 BCTM
Vtest64 BL1 NM64 0
X65 NM65 SL2 WL1 BCTM
Vtest65 BL2 NM65 0
X66 NM66 SL2 WL2 BCTM
Vtest66 BL2 NM66 0
X67 NM67 SL2 WL3 BCTM
Vtest67 BL2 NM67 0
X68 NM68 SL2 WL4 BCTM
Vtest68 BL2 NM68 0
X69 NM69 SL2 WL5 BCTM
Vtest69 BL2 NM69 0
X70 NM70 SL2 WL6 BCTM
Vtest70 BL2 NM70 0
X71 NM71 SL2 WL7 BCTM
Vtest71 BL2 NM71 0
X72 NM72 SL2 WL8 BCTM
Vtest72 BL2 NM72 0
X73 NM73 SL2 WL9 BCTM
Vtest73 BL2 NM73 0
X74 NM74 SL2 WL10 BCTM
Vtest74 BL2 NM74 0
X75 NM75 SL2 WL11 BCTM
Vtest75 BL2 NM75 0
X76 NM76 SL2 WL12 BCTM
Vtest76 BL2 NM76 0
X77 NM77 SL2 WL13 BCTM
Vtest77 BL2 NM77 0
X78 NM78 SL2 WL14 BCTM
Vtest78 BL2 NM78 0
X79 NM79 SL2 WL15 BCTM
Vtest79 BL2 NM79 0
X80 NM80 SL2 WL16 BCTM
Vtest80 BL2 NM80 0
X81 NM81 SL2 WL17 BCTM
Vtest81 BL2 NM81 0
X82 NM82 SL2 WL18 BCTM
Vtest82 BL2 NM82 0
X83 NM83 SL2 WL19 BCTM
Vtest83 BL2 NM83 0
X84 NM84 SL2 WL20 BCTM
Vtest84 BL2 NM84 0
X85 NM85 SL2 WL21 BCTM
Vtest85 BL2 NM85 0
X86 NM86 SL2 WL22 BCTM
Vtest86 BL2 NM86 0
X87 NM87 SL2 WL23 BCTM
Vtest87 BL2 NM87 0
X88 NM88 SL2 WL24 BCTM
Vtest88 BL2 NM88 0
X89 NM89 SL2 WL25 BCTM
Vtest89 BL2 NM89 0
X90 NM90 SL2 WL26 BCTM
Vtest90 BL2 NM90 0
X91 NM91 SL2 WL27 BCTM
Vtest91 BL2 NM91 0
X92 NM92 SL2 WL28 BCTM
Vtest92 BL2 NM92 0
X93 NM93 SL2 WL29 BCTM
Vtest93 BL2 NM93 0
X94 NM94 SL2 WL30 BCTM
Vtest94 BL2 NM94 0
X95 NM95 SL2 WL31 BCTM
Vtest95 BL2 NM95 0
X96 NM96 SL2 WL32 BCTM
Vtest96 BL2 NM96 0
X97 NM97 SL2 WL33 BCTM
Vtest97 BL2 NM97 0
X98 NM98 SL2 WL34 BCTM
Vtest98 BL2 NM98 0
X99 NM99 SL2 WL35 BCTM
Vtest99 BL2 NM99 0
X100 NM100 SL2 WL36 BCTM
Vtest100 BL2 NM100 0
X101 NM101 SL2 WL37 BCTM
Vtest101 BL2 NM101 0
X102 NM102 SL2 WL38 BCTM
Vtest102 BL2 NM102 0
X103 NM103 SL2 WL39 BCTM
Vtest103 BL2 NM103 0
X104 NM104 SL2 WL40 BCTM
Vtest104 BL2 NM104 0
X105 NM105 SL2 WL41 BCTM
Vtest105 BL2 NM105 0
X106 NM106 SL2 WL42 BCTM
Vtest106 BL2 NM106 0
X107 NM107 SL2 WL43 BCTM
Vtest107 BL2 NM107 0
X108 NM108 SL2 WL44 BCTM
Vtest108 BL2 NM108 0
X109 NM109 SL2 WL45 BCTM
Vtest109 BL2 NM109 0
X110 NM110 SL2 WL46 BCTM
Vtest110 BL2 NM110 0
X111 NM111 SL2 WL47 BCTM
Vtest111 BL2 NM111 0
X112 NM112 SL2 WL48 BCTM
Vtest112 BL2 NM112 0
X113 NM113 SL2 WL49 BCTM
Vtest113 BL2 NM113 0
X114 NM114 SL2 WL50 BCTM
Vtest114 BL2 NM114 0
X115 NM115 SL2 WL51 BCTM
Vtest115 BL2 NM115 0
X116 NM116 SL2 WL52 BCTM
Vtest116 BL2 NM116 0
X117 NM117 SL2 WL53 BCTM
Vtest117 BL2 NM117 0
X118 NM118 SL2 WL54 BCTM
Vtest118 BL2 NM118 0
X119 NM119 SL2 WL55 BCTM
Vtest119 BL2 NM119 0
X120 NM120 SL2 WL56 BCTM
Vtest120 BL2 NM120 0
X121 NM121 SL2 WL57 BCTM
Vtest121 BL2 NM121 0
X122 NM122 SL2 WL58 BCTM
Vtest122 BL2 NM122 0
X123 NM123 SL2 WL59 BCTM
Vtest123 BL2 NM123 0
X124 NM124 SL2 WL60 BCTM
Vtest124 BL2 NM124 0
X125 NM125 SL2 WL61 BCTM
Vtest125 BL2 NM125 0
X126 NM126 SL2 WL62 BCTM
Vtest126 BL2 NM126 0
X127 NM127 SL2 WL63 BCTM
Vtest127 BL2 NM127 0
X128 NM128 SL2 WL64 BCTM
Vtest128 BL2 NM128 0
X129 NM129 SL3 WL1 BCTM
Vtest129 BL3 NM129 0
X130 NM130 SL3 WL2 BCTM
Vtest130 BL3 NM130 0
X131 NM131 SL3 WL3 BCTM
Vtest131 BL3 NM131 0
X132 NM132 SL3 WL4 BCTM
Vtest132 BL3 NM132 0
X133 NM133 SL3 WL5 BCTM
Vtest133 BL3 NM133 0
X134 NM134 SL3 WL6 BCTM
Vtest134 BL3 NM134 0
X135 NM135 SL3 WL7 BCTM
Vtest135 BL3 NM135 0
X136 NM136 SL3 WL8 BCTM
Vtest136 BL3 NM136 0
X137 NM137 SL3 WL9 BCTM
Vtest137 BL3 NM137 0
X138 NM138 SL3 WL10 BCTM
Vtest138 BL3 NM138 0
X139 NM139 SL3 WL11 BCTM
Vtest139 BL3 NM139 0
X140 NM140 SL3 WL12 BCTM
Vtest140 BL3 NM140 0
X141 NM141 SL3 WL13 BCTM
Vtest141 BL3 NM141 0
X142 NM142 SL3 WL14 BCTM
Vtest142 BL3 NM142 0
X143 NM143 SL3 WL15 BCTM
Vtest143 BL3 NM143 0
X144 NM144 SL3 WL16 BCTM
Vtest144 BL3 NM144 0
X145 NM145 SL3 WL17 BCTM
Vtest145 BL3 NM145 0
X146 NM146 SL3 WL18 BCTM
Vtest146 BL3 NM146 0
X147 NM147 SL3 WL19 BCTM
Vtest147 BL3 NM147 0
X148 NM148 SL3 WL20 BCTM
Vtest148 BL3 NM148 0
X149 NM149 SL3 WL21 BCTM
Vtest149 BL3 NM149 0
X150 NM150 SL3 WL22 BCTM
Vtest150 BL3 NM150 0
X151 NM151 SL3 WL23 BCTM
Vtest151 BL3 NM151 0
X152 NM152 SL3 WL24 BCTM
Vtest152 BL3 NM152 0
X153 NM153 SL3 WL25 BCTM
Vtest153 BL3 NM153 0
X154 NM154 SL3 WL26 BCTM
Vtest154 BL3 NM154 0
X155 NM155 SL3 WL27 BCTM
Vtest155 BL3 NM155 0
X156 NM156 SL3 WL28 BCTM
Vtest156 BL3 NM156 0
X157 NM157 SL3 WL29 BCTM
Vtest157 BL3 NM157 0
X158 NM158 SL3 WL30 BCTM
Vtest158 BL3 NM158 0
X159 NM159 SL3 WL31 BCTM
Vtest159 BL3 NM159 0
X160 NM160 SL3 WL32 BCTM
Vtest160 BL3 NM160 0
X161 NM161 SL3 WL33 BCTM
Vtest161 BL3 NM161 0
X162 NM162 SL3 WL34 BCTM
Vtest162 BL3 NM162 0
X163 NM163 SL3 WL35 BCTM
Vtest163 BL3 NM163 0
X164 NM164 SL3 WL36 BCTM
Vtest164 BL3 NM164 0
X165 NM165 SL3 WL37 BCTM
Vtest165 BL3 NM165 0
X166 NM166 SL3 WL38 BCTM
Vtest166 BL3 NM166 0
X167 NM167 SL3 WL39 BCTM
Vtest167 BL3 NM167 0
X168 NM168 SL3 WL40 BCTM
Vtest168 BL3 NM168 0
X169 NM169 SL3 WL41 BCTM
Vtest169 BL3 NM169 0
X170 NM170 SL3 WL42 BCTM
Vtest170 BL3 NM170 0
X171 NM171 SL3 WL43 BCTM
Vtest171 BL3 NM171 0
X172 NM172 SL3 WL44 BCTM
Vtest172 BL3 NM172 0
X173 NM173 SL3 WL45 BCTM
Vtest173 BL3 NM173 0
X174 NM174 SL3 WL46 BCTM
Vtest174 BL3 NM174 0
X175 NM175 SL3 WL47 BCTM
Vtest175 BL3 NM175 0
X176 NM176 SL3 WL48 BCTM
Vtest176 BL3 NM176 0
X177 NM177 SL3 WL49 BCTM
Vtest177 BL3 NM177 0
X178 NM178 SL3 WL50 BCTM
Vtest178 BL3 NM178 0
X179 NM179 SL3 WL51 BCTM
Vtest179 BL3 NM179 0
X180 NM180 SL3 WL52 BCTM
Vtest180 BL3 NM180 0
X181 NM181 SL3 WL53 BCTM
Vtest181 BL3 NM181 0
X182 NM182 SL3 WL54 BCTM
Vtest182 BL3 NM182 0
X183 NM183 SL3 WL55 BCTM
Vtest183 BL3 NM183 0
X184 NM184 SL3 WL56 BCTM
Vtest184 BL3 NM184 0
X185 NM185 SL3 WL57 BCTM
Vtest185 BL3 NM185 0
X186 NM186 SL3 WL58 BCTM
Vtest186 BL3 NM186 0
X187 NM187 SL3 WL59 BCTM
Vtest187 BL3 NM187 0
X188 NM188 SL3 WL60 BCTM
Vtest188 BL3 NM188 0
X189 NM189 SL3 WL61 BCTM
Vtest189 BL3 NM189 0
X190 NM190 SL3 WL62 BCTM
Vtest190 BL3 NM190 0
X191 NM191 SL3 WL63 BCTM
Vtest191 BL3 NM191 0
X192 NM192 SL3 WL64 BCTM
Vtest192 BL3 NM192 0
X193 NM193 SL4 WL1 BCTM
Vtest193 BL4 NM193 0
X194 NM194 SL4 WL2 BCTM
Vtest194 BL4 NM194 0
X195 NM195 SL4 WL3 BCTM
Vtest195 BL4 NM195 0
X196 NM196 SL4 WL4 BCTM
Vtest196 BL4 NM196 0
X197 NM197 SL4 WL5 BCTM
Vtest197 BL4 NM197 0
X198 NM198 SL4 WL6 BCTM
Vtest198 BL4 NM198 0
X199 NM199 SL4 WL7 BCTM
Vtest199 BL4 NM199 0
X200 NM200 SL4 WL8 BCTM
Vtest200 BL4 NM200 0
X201 NM201 SL4 WL9 BCTM
Vtest201 BL4 NM201 0
X202 NM202 SL4 WL10 BCTM
Vtest202 BL4 NM202 0
X203 NM203 SL4 WL11 BCTM
Vtest203 BL4 NM203 0
X204 NM204 SL4 WL12 BCTM
Vtest204 BL4 NM204 0
X205 NM205 SL4 WL13 BCTM
Vtest205 BL4 NM205 0
X206 NM206 SL4 WL14 BCTM
Vtest206 BL4 NM206 0
X207 NM207 SL4 WL15 BCTM
Vtest207 BL4 NM207 0
X208 NM208 SL4 WL16 BCTM
Vtest208 BL4 NM208 0
X209 NM209 SL4 WL17 BCTM
Vtest209 BL4 NM209 0
X210 NM210 SL4 WL18 BCTM
Vtest210 BL4 NM210 0
X211 NM211 SL4 WL19 BCTM
Vtest211 BL4 NM211 0
X212 NM212 SL4 WL20 BCTM
Vtest212 BL4 NM212 0
X213 NM213 SL4 WL21 BCTM
Vtest213 BL4 NM213 0
X214 NM214 SL4 WL22 BCTM
Vtest214 BL4 NM214 0
X215 NM215 SL4 WL23 BCTM
Vtest215 BL4 NM215 0
X216 NM216 SL4 WL24 BCTM
Vtest216 BL4 NM216 0
X217 NM217 SL4 WL25 BCTM
Vtest217 BL4 NM217 0
X218 NM218 SL4 WL26 BCTM
Vtest218 BL4 NM218 0
X219 NM219 SL4 WL27 BCTM
Vtest219 BL4 NM219 0
X220 NM220 SL4 WL28 BCTM
Vtest220 BL4 NM220 0
X221 NM221 SL4 WL29 BCTM
Vtest221 BL4 NM221 0
X222 NM222 SL4 WL30 BCTM
Vtest222 BL4 NM222 0
X223 NM223 SL4 WL31 BCTM
Vtest223 BL4 NM223 0
X224 NM224 SL4 WL32 BCTM
Vtest224 BL4 NM224 0
X225 NM225 SL4 WL33 BCTM
Vtest225 BL4 NM225 0
X226 NM226 SL4 WL34 BCTM
Vtest226 BL4 NM226 0
X227 NM227 SL4 WL35 BCTM
Vtest227 BL4 NM227 0
X228 NM228 SL4 WL36 BCTM
Vtest228 BL4 NM228 0
X229 NM229 SL4 WL37 BCTM
Vtest229 BL4 NM229 0
X230 NM230 SL4 WL38 BCTM
Vtest230 BL4 NM230 0
X231 NM231 SL4 WL39 BCTM
Vtest231 BL4 NM231 0
X232 NM232 SL4 WL40 BCTM
Vtest232 BL4 NM232 0
X233 NM233 SL4 WL41 BCTM
Vtest233 BL4 NM233 0
X234 NM234 SL4 WL42 BCTM
Vtest234 BL4 NM234 0
X235 NM235 SL4 WL43 BCTM
Vtest235 BL4 NM235 0
X236 NM236 SL4 WL44 BCTM
Vtest236 BL4 NM236 0
X237 NM237 SL4 WL45 BCTM
Vtest237 BL4 NM237 0
X238 NM238 SL4 WL46 BCTM
Vtest238 BL4 NM238 0
X239 NM239 SL4 WL47 BCTM
Vtest239 BL4 NM239 0
X240 NM240 SL4 WL48 BCTM
Vtest240 BL4 NM240 0
X241 NM241 SL4 WL49 BCTM
Vtest241 BL4 NM241 0
X242 NM242 SL4 WL50 BCTM
Vtest242 BL4 NM242 0
X243 NM243 SL4 WL51 BCTM
Vtest243 BL4 NM243 0
X244 NM244 SL4 WL52 BCTM
Vtest244 BL4 NM244 0
X245 NM245 SL4 WL53 BCTM
Vtest245 BL4 NM245 0
X246 NM246 SL4 WL54 BCTM
Vtest246 BL4 NM246 0
X247 NM247 SL4 WL55 BCTM
Vtest247 BL4 NM247 0
X248 NM248 SL4 WL56 BCTM
Vtest248 BL4 NM248 0
X249 NM249 SL4 WL57 BCTM
Vtest249 BL4 NM249 0
X250 NM250 SL4 WL58 BCTM
Vtest250 BL4 NM250 0
X251 NM251 SL4 WL59 BCTM
Vtest251 BL4 NM251 0
X252 NM252 SL4 WL60 BCTM
Vtest252 BL4 NM252 0
X253 NM253 SL4 WL61 BCTM
Vtest253 BL4 NM253 0
X254 NM254 SL4 WL62 BCTM
Vtest254 BL4 NM254 0
X255 NM255 SL4 WL63 BCTM
Vtest255 BL4 NM255 0
X256 NM256 SL4 WL64 BCTM
Vtest256 BL4 NM256 0
X257 NM257 SL5 WL1 BCTM
Vtest257 BL5 NM257 0
X258 NM258 SL5 WL2 BCTM
Vtest258 BL5 NM258 0
X259 NM259 SL5 WL3 BCTM
Vtest259 BL5 NM259 0
X260 NM260 SL5 WL4 BCTM
Vtest260 BL5 NM260 0
X261 NM261 SL5 WL5 BCTM
Vtest261 BL5 NM261 0
X262 NM262 SL5 WL6 BCTM
Vtest262 BL5 NM262 0
X263 NM263 SL5 WL7 BCTM
Vtest263 BL5 NM263 0
X264 NM264 SL5 WL8 BCTM
Vtest264 BL5 NM264 0
X265 NM265 SL5 WL9 BCTM
Vtest265 BL5 NM265 0
X266 NM266 SL5 WL10 BCTM
Vtest266 BL5 NM266 0
X267 NM267 SL5 WL11 BCTM
Vtest267 BL5 NM267 0
X268 NM268 SL5 WL12 BCTM
Vtest268 BL5 NM268 0
X269 NM269 SL5 WL13 BCTM
Vtest269 BL5 NM269 0
X270 NM270 SL5 WL14 BCTM
Vtest270 BL5 NM270 0
X271 NM271 SL5 WL15 BCTM
Vtest271 BL5 NM271 0
X272 NM272 SL5 WL16 BCTM
Vtest272 BL5 NM272 0
X273 NM273 SL5 WL17 BCTM
Vtest273 BL5 NM273 0
X274 NM274 SL5 WL18 BCTM
Vtest274 BL5 NM274 0
X275 NM275 SL5 WL19 BCTM
Vtest275 BL5 NM275 0
X276 NM276 SL5 WL20 BCTM
Vtest276 BL5 NM276 0
X277 NM277 SL5 WL21 BCTM
Vtest277 BL5 NM277 0
X278 NM278 SL5 WL22 BCTM
Vtest278 BL5 NM278 0
X279 NM279 SL5 WL23 BCTM
Vtest279 BL5 NM279 0
X280 NM280 SL5 WL24 BCTM
Vtest280 BL5 NM280 0
X281 NM281 SL5 WL25 BCTM
Vtest281 BL5 NM281 0
X282 NM282 SL5 WL26 BCTM
Vtest282 BL5 NM282 0
X283 NM283 SL5 WL27 BCTM
Vtest283 BL5 NM283 0
X284 NM284 SL5 WL28 BCTM
Vtest284 BL5 NM284 0
X285 NM285 SL5 WL29 BCTM
Vtest285 BL5 NM285 0
X286 NM286 SL5 WL30 BCTM
Vtest286 BL5 NM286 0
X287 NM287 SL5 WL31 BCTM
Vtest287 BL5 NM287 0
X288 NM288 SL5 WL32 BCTM
Vtest288 BL5 NM288 0
X289 NM289 SL5 WL33 BCTM
Vtest289 BL5 NM289 0
X290 NM290 SL5 WL34 BCTM
Vtest290 BL5 NM290 0
X291 NM291 SL5 WL35 BCTM
Vtest291 BL5 NM291 0
X292 NM292 SL5 WL36 BCTM
Vtest292 BL5 NM292 0
X293 NM293 SL5 WL37 BCTM
Vtest293 BL5 NM293 0
X294 NM294 SL5 WL38 BCTM
Vtest294 BL5 NM294 0
X295 NM295 SL5 WL39 BCTM
Vtest295 BL5 NM295 0
X296 NM296 SL5 WL40 BCTM
Vtest296 BL5 NM296 0
X297 NM297 SL5 WL41 BCTM
Vtest297 BL5 NM297 0
X298 NM298 SL5 WL42 BCTM
Vtest298 BL5 NM298 0
X299 NM299 SL5 WL43 BCTM
Vtest299 BL5 NM299 0
X300 NM300 SL5 WL44 BCTM
Vtest300 BL5 NM300 0
X301 NM301 SL5 WL45 BCTM
Vtest301 BL5 NM301 0
X302 NM302 SL5 WL46 BCTM
Vtest302 BL5 NM302 0
X303 NM303 SL5 WL47 BCTM
Vtest303 BL5 NM303 0
X304 NM304 SL5 WL48 BCTM
Vtest304 BL5 NM304 0
X305 NM305 SL5 WL49 BCTM
Vtest305 BL5 NM305 0
X306 NM306 SL5 WL50 BCTM
Vtest306 BL5 NM306 0
X307 NM307 SL5 WL51 BCTM
Vtest307 BL5 NM307 0
X308 NM308 SL5 WL52 BCTM
Vtest308 BL5 NM308 0
X309 NM309 SL5 WL53 BCTM
Vtest309 BL5 NM309 0
X310 NM310 SL5 WL54 BCTM
Vtest310 BL5 NM310 0
X311 NM311 SL5 WL55 BCTM
Vtest311 BL5 NM311 0
X312 NM312 SL5 WL56 BCTM
Vtest312 BL5 NM312 0
X313 NM313 SL5 WL57 BCTM
Vtest313 BL5 NM313 0
X314 NM314 SL5 WL58 BCTM
Vtest314 BL5 NM314 0
X315 NM315 SL5 WL59 BCTM
Vtest315 BL5 NM315 0
X316 NM316 SL5 WL60 BCTM
Vtest316 BL5 NM316 0
X317 NM317 SL5 WL61 BCTM
Vtest317 BL5 NM317 0
X318 NM318 SL5 WL62 BCTM
Vtest318 BL5 NM318 0
X319 NM319 SL5 WL63 BCTM
Vtest319 BL5 NM319 0
X320 NM320 SL5 WL64 BCTM
Vtest320 BL5 NM320 0
X321 NM321 SL6 WL1 BCTM
Vtest321 BL6 NM321 0
X322 NM322 SL6 WL2 BCTM
Vtest322 BL6 NM322 0
X323 NM323 SL6 WL3 BCTM
Vtest323 BL6 NM323 0
X324 NM324 SL6 WL4 BCTM
Vtest324 BL6 NM324 0
X325 NM325 SL6 WL5 BCTM
Vtest325 BL6 NM325 0
X326 NM326 SL6 WL6 BCTM
Vtest326 BL6 NM326 0
X327 NM327 SL6 WL7 BCTM
Vtest327 BL6 NM327 0
X328 NM328 SL6 WL8 BCTM
Vtest328 BL6 NM328 0
X329 NM329 SL6 WL9 BCTM
Vtest329 BL6 NM329 0
X330 NM330 SL6 WL10 BCTM
Vtest330 BL6 NM330 0
X331 NM331 SL6 WL11 BCTM
Vtest331 BL6 NM331 0
X332 NM332 SL6 WL12 BCTM
Vtest332 BL6 NM332 0
X333 NM333 SL6 WL13 BCTM
Vtest333 BL6 NM333 0
X334 NM334 SL6 WL14 BCTM
Vtest334 BL6 NM334 0
X335 NM335 SL6 WL15 BCTM
Vtest335 BL6 NM335 0
X336 NM336 SL6 WL16 BCTM
Vtest336 BL6 NM336 0
X337 NM337 SL6 WL17 BCTM
Vtest337 BL6 NM337 0
X338 NM338 SL6 WL18 BCTM
Vtest338 BL6 NM338 0
X339 NM339 SL6 WL19 BCTM
Vtest339 BL6 NM339 0
X340 NM340 SL6 WL20 BCTM
Vtest340 BL6 NM340 0
X341 NM341 SL6 WL21 BCTM
Vtest341 BL6 NM341 0
X342 NM342 SL6 WL22 BCTM
Vtest342 BL6 NM342 0
X343 NM343 SL6 WL23 BCTM
Vtest343 BL6 NM343 0
X344 NM344 SL6 WL24 BCTM
Vtest344 BL6 NM344 0
X345 NM345 SL6 WL25 BCTM
Vtest345 BL6 NM345 0
X346 NM346 SL6 WL26 BCTM
Vtest346 BL6 NM346 0
X347 NM347 SL6 WL27 BCTM
Vtest347 BL6 NM347 0
X348 NM348 SL6 WL28 BCTM
Vtest348 BL6 NM348 0
X349 NM349 SL6 WL29 BCTM
Vtest349 BL6 NM349 0
X350 NM350 SL6 WL30 BCTM
Vtest350 BL6 NM350 0
X351 NM351 SL6 WL31 BCTM
Vtest351 BL6 NM351 0
X352 NM352 SL6 WL32 BCTM
Vtest352 BL6 NM352 0
X353 NM353 SL6 WL33 BCTM
Vtest353 BL6 NM353 0
X354 NM354 SL6 WL34 BCTM
Vtest354 BL6 NM354 0
X355 NM355 SL6 WL35 BCTM
Vtest355 BL6 NM355 0
X356 NM356 SL6 WL36 BCTM
Vtest356 BL6 NM356 0
X357 NM357 SL6 WL37 BCTM
Vtest357 BL6 NM357 0
X358 NM358 SL6 WL38 BCTM
Vtest358 BL6 NM358 0
X359 NM359 SL6 WL39 BCTM
Vtest359 BL6 NM359 0
X360 NM360 SL6 WL40 BCTM
Vtest360 BL6 NM360 0
X361 NM361 SL6 WL41 BCTM
Vtest361 BL6 NM361 0
X362 NM362 SL6 WL42 BCTM
Vtest362 BL6 NM362 0
X363 NM363 SL6 WL43 BCTM
Vtest363 BL6 NM363 0
X364 NM364 SL6 WL44 BCTM
Vtest364 BL6 NM364 0
X365 NM365 SL6 WL45 BCTM
Vtest365 BL6 NM365 0
X366 NM366 SL6 WL46 BCTM
Vtest366 BL6 NM366 0
X367 NM367 SL6 WL47 BCTM
Vtest367 BL6 NM367 0
X368 NM368 SL6 WL48 BCTM
Vtest368 BL6 NM368 0
X369 NM369 SL6 WL49 BCTM
Vtest369 BL6 NM369 0
X370 NM370 SL6 WL50 BCTM
Vtest370 BL6 NM370 0
X371 NM371 SL6 WL51 BCTM
Vtest371 BL6 NM371 0
X372 NM372 SL6 WL52 BCTM
Vtest372 BL6 NM372 0
X373 NM373 SL6 WL53 BCTM
Vtest373 BL6 NM373 0
X374 NM374 SL6 WL54 BCTM
Vtest374 BL6 NM374 0
X375 NM375 SL6 WL55 BCTM
Vtest375 BL6 NM375 0
X376 NM376 SL6 WL56 BCTM
Vtest376 BL6 NM376 0
X377 NM377 SL6 WL57 BCTM
Vtest377 BL6 NM377 0
X378 NM378 SL6 WL58 BCTM
Vtest378 BL6 NM378 0
X379 NM379 SL6 WL59 BCTM
Vtest379 BL6 NM379 0
X380 NM380 SL6 WL60 BCTM
Vtest380 BL6 NM380 0
X381 NM381 SL6 WL61 BCTM
Vtest381 BL6 NM381 0
X382 NM382 SL6 WL62 BCTM
Vtest382 BL6 NM382 0
X383 NM383 SL6 WL63 BCTM
Vtest383 BL6 NM383 0
X384 NM384 SL6 WL64 BCTM
Vtest384 BL6 NM384 0
X385 NM385 SL7 WL1 BCTM
Vtest385 BL7 NM385 0
X386 NM386 SL7 WL2 BCTM
Vtest386 BL7 NM386 0
X387 NM387 SL7 WL3 BCTM
Vtest387 BL7 NM387 0
X388 NM388 SL7 WL4 BCTM
Vtest388 BL7 NM388 0
X389 NM389 SL7 WL5 BCTM
Vtest389 BL7 NM389 0
X390 NM390 SL7 WL6 BCTM
Vtest390 BL7 NM390 0
X391 NM391 SL7 WL7 BCTM
Vtest391 BL7 NM391 0
X392 NM392 SL7 WL8 BCTM
Vtest392 BL7 NM392 0
X393 NM393 SL7 WL9 BCTM
Vtest393 BL7 NM393 0
X394 NM394 SL7 WL10 BCTM
Vtest394 BL7 NM394 0
X395 NM395 SL7 WL11 BCTM
Vtest395 BL7 NM395 0
X396 NM396 SL7 WL12 BCTM
Vtest396 BL7 NM396 0
X397 NM397 SL7 WL13 BCTM
Vtest397 BL7 NM397 0
X398 NM398 SL7 WL14 BCTM
Vtest398 BL7 NM398 0
X399 NM399 SL7 WL15 BCTM
Vtest399 BL7 NM399 0
X400 NM400 SL7 WL16 BCTM
Vtest400 BL7 NM400 0
X401 NM401 SL7 WL17 BCTM
Vtest401 BL7 NM401 0
X402 NM402 SL7 WL18 BCTM
Vtest402 BL7 NM402 0
X403 NM403 SL7 WL19 BCTM
Vtest403 BL7 NM403 0
X404 NM404 SL7 WL20 BCTM
Vtest404 BL7 NM404 0
X405 NM405 SL7 WL21 BCTM
Vtest405 BL7 NM405 0
X406 NM406 SL7 WL22 BCTM
Vtest406 BL7 NM406 0
X407 NM407 SL7 WL23 BCTM
Vtest407 BL7 NM407 0
X408 NM408 SL7 WL24 BCTM
Vtest408 BL7 NM408 0
X409 NM409 SL7 WL25 BCTM
Vtest409 BL7 NM409 0
X410 NM410 SL7 WL26 BCTM
Vtest410 BL7 NM410 0
X411 NM411 SL7 WL27 BCTM
Vtest411 BL7 NM411 0
X412 NM412 SL7 WL28 BCTM
Vtest412 BL7 NM412 0
X413 NM413 SL7 WL29 BCTM
Vtest413 BL7 NM413 0
X414 NM414 SL7 WL30 BCTM
Vtest414 BL7 NM414 0
X415 NM415 SL7 WL31 BCTM
Vtest415 BL7 NM415 0
X416 NM416 SL7 WL32 BCTM
Vtest416 BL7 NM416 0
X417 NM417 SL7 WL33 BCTM
Vtest417 BL7 NM417 0
X418 NM418 SL7 WL34 BCTM
Vtest418 BL7 NM418 0
X419 NM419 SL7 WL35 BCTM
Vtest419 BL7 NM419 0
X420 NM420 SL7 WL36 BCTM
Vtest420 BL7 NM420 0
X421 NM421 SL7 WL37 BCTM
Vtest421 BL7 NM421 0
X422 NM422 SL7 WL38 BCTM
Vtest422 BL7 NM422 0
X423 NM423 SL7 WL39 BCTM
Vtest423 BL7 NM423 0
X424 NM424 SL7 WL40 BCTM
Vtest424 BL7 NM424 0
X425 NM425 SL7 WL41 BCTM
Vtest425 BL7 NM425 0
X426 NM426 SL7 WL42 BCTM
Vtest426 BL7 NM426 0
X427 NM427 SL7 WL43 BCTM
Vtest427 BL7 NM427 0
X428 NM428 SL7 WL44 BCTM
Vtest428 BL7 NM428 0
X429 NM429 SL7 WL45 BCTM
Vtest429 BL7 NM429 0
X430 NM430 SL7 WL46 BCTM
Vtest430 BL7 NM430 0
X431 NM431 SL7 WL47 BCTM
Vtest431 BL7 NM431 0
X432 NM432 SL7 WL48 BCTM
Vtest432 BL7 NM432 0
X433 NM433 SL7 WL49 BCTM
Vtest433 BL7 NM433 0
X434 NM434 SL7 WL50 BCTM
Vtest434 BL7 NM434 0
X435 NM435 SL7 WL51 BCTM
Vtest435 BL7 NM435 0
X436 NM436 SL7 WL52 BCTM
Vtest436 BL7 NM436 0
X437 NM437 SL7 WL53 BCTM
Vtest437 BL7 NM437 0
X438 NM438 SL7 WL54 BCTM
Vtest438 BL7 NM438 0
X439 NM439 SL7 WL55 BCTM
Vtest439 BL7 NM439 0
X440 NM440 SL7 WL56 BCTM
Vtest440 BL7 NM440 0
X441 NM441 SL7 WL57 BCTM
Vtest441 BL7 NM441 0
X442 NM442 SL7 WL58 BCTM
Vtest442 BL7 NM442 0
X443 NM443 SL7 WL59 BCTM
Vtest443 BL7 NM443 0
X444 NM444 SL7 WL60 BCTM
Vtest444 BL7 NM444 0
X445 NM445 SL7 WL61 BCTM
Vtest445 BL7 NM445 0
X446 NM446 SL7 WL62 BCTM
Vtest446 BL7 NM446 0
X447 NM447 SL7 WL63 BCTM
Vtest447 BL7 NM447 0
X448 NM448 SL7 WL64 BCTM
Vtest448 BL7 NM448 0
X449 NM449 SL8 WL1 BCTM
Vtest449 BL8 NM449 0
X450 NM450 SL8 WL2 BCTM
Vtest450 BL8 NM450 0
X451 NM451 SL8 WL3 BCTM
Vtest451 BL8 NM451 0
X452 NM452 SL8 WL4 BCTM
Vtest452 BL8 NM452 0
X453 NM453 SL8 WL5 BCTM
Vtest453 BL8 NM453 0
X454 NM454 SL8 WL6 BCTM
Vtest454 BL8 NM454 0
X455 NM455 SL8 WL7 BCTM
Vtest455 BL8 NM455 0
X456 NM456 SL8 WL8 BCTM
Vtest456 BL8 NM456 0
X457 NM457 SL8 WL9 BCTM
Vtest457 BL8 NM457 0
X458 NM458 SL8 WL10 BCTM
Vtest458 BL8 NM458 0
X459 NM459 SL8 WL11 BCTM
Vtest459 BL8 NM459 0
X460 NM460 SL8 WL12 BCTM
Vtest460 BL8 NM460 0
X461 NM461 SL8 WL13 BCTM
Vtest461 BL8 NM461 0
X462 NM462 SL8 WL14 BCTM
Vtest462 BL8 NM462 0
X463 NM463 SL8 WL15 BCTM
Vtest463 BL8 NM463 0
X464 NM464 SL8 WL16 BCTM
Vtest464 BL8 NM464 0
X465 NM465 SL8 WL17 BCTM
Vtest465 BL8 NM465 0
X466 NM466 SL8 WL18 BCTM
Vtest466 BL8 NM466 0
X467 NM467 SL8 WL19 BCTM
Vtest467 BL8 NM467 0
X468 NM468 SL8 WL20 BCTM
Vtest468 BL8 NM468 0
X469 NM469 SL8 WL21 BCTM
Vtest469 BL8 NM469 0
X470 NM470 SL8 WL22 BCTM
Vtest470 BL8 NM470 0
X471 NM471 SL8 WL23 BCTM
Vtest471 BL8 NM471 0
X472 NM472 SL8 WL24 BCTM
Vtest472 BL8 NM472 0
X473 NM473 SL8 WL25 BCTM
Vtest473 BL8 NM473 0
X474 NM474 SL8 WL26 BCTM
Vtest474 BL8 NM474 0
X475 NM475 SL8 WL27 BCTM
Vtest475 BL8 NM475 0
X476 NM476 SL8 WL28 BCTM
Vtest476 BL8 NM476 0
X477 NM477 SL8 WL29 BCTM
Vtest477 BL8 NM477 0
X478 NM478 SL8 WL30 BCTM
Vtest478 BL8 NM478 0
X479 NM479 SL8 WL31 BCTM
Vtest479 BL8 NM479 0
X480 NM480 SL8 WL32 BCTM
Vtest480 BL8 NM480 0
X481 NM481 SL8 WL33 BCTM
Vtest481 BL8 NM481 0
X482 NM482 SL8 WL34 BCTM
Vtest482 BL8 NM482 0
X483 NM483 SL8 WL35 BCTM
Vtest483 BL8 NM483 0
X484 NM484 SL8 WL36 BCTM
Vtest484 BL8 NM484 0
X485 NM485 SL8 WL37 BCTM
Vtest485 BL8 NM485 0
X486 NM486 SL8 WL38 BCTM
Vtest486 BL8 NM486 0
X487 NM487 SL8 WL39 BCTM
Vtest487 BL8 NM487 0
X488 NM488 SL8 WL40 BCTM
Vtest488 BL8 NM488 0
X489 NM489 SL8 WL41 BCTM
Vtest489 BL8 NM489 0
X490 NM490 SL8 WL42 BCTM
Vtest490 BL8 NM490 0
X491 NM491 SL8 WL43 BCTM
Vtest491 BL8 NM491 0
X492 NM492 SL8 WL44 BCTM
Vtest492 BL8 NM492 0
X493 NM493 SL8 WL45 BCTM
Vtest493 BL8 NM493 0
X494 NM494 SL8 WL46 BCTM
Vtest494 BL8 NM494 0
X495 NM495 SL8 WL47 BCTM
Vtest495 BL8 NM495 0
X496 NM496 SL8 WL48 BCTM
Vtest496 BL8 NM496 0
X497 NM497 SL8 WL49 BCTM
Vtest497 BL8 NM497 0
X498 NM498 SL8 WL50 BCTM
Vtest498 BL8 NM498 0
X499 NM499 SL8 WL51 BCTM
Vtest499 BL8 NM499 0
X500 NM500 SL8 WL52 BCTM
Vtest500 BL8 NM500 0
X501 NM501 SL8 WL53 BCTM
Vtest501 BL8 NM501 0
X502 NM502 SL8 WL54 BCTM
Vtest502 BL8 NM502 0
X503 NM503 SL8 WL55 BCTM
Vtest503 BL8 NM503 0
X504 NM504 SL8 WL56 BCTM
Vtest504 BL8 NM504 0
X505 NM505 SL8 WL57 BCTM
Vtest505 BL8 NM505 0
X506 NM506 SL8 WL58 BCTM
Vtest506 BL8 NM506 0
X507 NM507 SL8 WL59 BCTM
Vtest507 BL8 NM507 0
X508 NM508 SL8 WL60 BCTM
Vtest508 BL8 NM508 0
X509 NM509 SL8 WL61 BCTM
Vtest509 BL8 NM509 0
X510 NM510 SL8 WL62 BCTM
Vtest510 BL8 NM510 0
X511 NM511 SL8 WL63 BCTM
Vtest511 BL8 NM511 0
X512 NM512 SL8 WL64 BCTM
Vtest512 BL8 NM512 0

* tristates

X514 WL1T WL1 ENWl Vdd Gnd TG
X515 WL2T WL2 ENWl Vdd Gnd TG
X516 WL3T WL3 ENWl Vdd Gnd TG
X517 WL4T WL4 ENWl Vdd Gnd TG
X518 WL5T WL5 ENWl Vdd Gnd TG
X519 WL6T WL6 ENWl Vdd Gnd TG
X520 WL7T WL7 ENWl Vdd Gnd TG
X521 WL8T WL8 ENWl Vdd Gnd TG
X522 WL9T WL9 ENWl Vdd Gnd TG
X523 WL10T WL10 ENWl Vdd Gnd TG
X524 WL11T WL11 ENWl Vdd Gnd TG
X525 WL12T WL12 ENWl Vdd Gnd TG
X526 WL13T WL13 ENWl Vdd Gnd TG
X527 WL14T WL14 ENWl Vdd Gnd TG
X528 WL15T WL15 ENWl Vdd Gnd TG
X529 WL16T WL16 ENWl Vdd Gnd TG
X530 WL17T WL17 ENWl Vdd Gnd TG
X531 WL18T WL18 ENWl Vdd Gnd TG
X532 WL19T WL19 ENWl Vdd Gnd TG
X533 WL20T WL20 ENWl Vdd Gnd TG
X534 WL21T WL21 ENWl Vdd Gnd TG
X535 WL22T WL22 ENWl Vdd Gnd TG
X536 WL23T WL23 ENWl Vdd Gnd TG
X537 WL24T WL24 ENWl Vdd Gnd TG
X538 WL25T WL25 ENWl Vdd Gnd TG
X539 WL26T WL26 ENWl Vdd Gnd TG
X540 WL27T WL27 ENWl Vdd Gnd TG
X541 WL28T WL28 ENWl Vdd Gnd TG
X542 WL29T WL29 ENWl Vdd Gnd TG
X543 WL30T WL30 ENWl Vdd Gnd TG
X544 WL31T WL31 ENWl Vdd Gnd TG
X545 WL32T WL32 ENWl1 Vdd Gnd TG
X546 WL33T WL33 ENWl Vdd Gnd TG
X547 WL34T WL34 ENWl Vdd Gnd TG
X548 WL35T WL35 ENWl Vdd Gnd TG
X549 WL36T WL36 ENWl Vdd Gnd TG
X550 WL37T WL37 ENWl Vdd Gnd TG
X551 WL38T WL38 ENWl Vdd Gnd TG
X552 WL39T WL39 ENWl Vdd Gnd TG
X553 WL40T WL40 ENWl Vdd Gnd TG
X554 WL41T WL41 ENWl Vdd Gnd TG
X555 WL42T WL42 ENWl Vdd Gnd TG
X556 WL43T WL43 ENWl Vdd Gnd TG
X557 WL44T WL44 ENWl Vdd Gnd TG
X558 WL45T WL45 ENWl Vdd Gnd TG
X559 WL46T WL46 ENWl Vdd Gnd TG
X560 WL47T WL47 ENWl Vdd Gnd TG
X561 WL48T WL48 ENWl Vdd Gnd TG
X562 WL49T WL49 ENWl Vdd Gnd TG
X563 WL50T WL50 ENWl Vdd Gnd TG
X564 WL51T WL51 ENWl Vdd Gnd TG
X565 WL52T WL52 ENWl Vdd Gnd TG
X566 WL53T WL53 ENWl Vdd Gnd TG
X567 WL54T WL54 ENWl Vdd Gnd TG
X568 WL55T WL55 ENWl Vdd Gnd TG
X569 WL56T WL56 ENWl Vdd Gnd TG
X570 WL57T WL57 ENWl Vdd Gnd TG
X571 WL58T WL58 ENWl Vdd Gnd TG
X572 WL59T WL59 ENWl Vdd Gnd TG
X573 WL60T WL60 ENWl Vdd Gnd TG
X574 WL61T WL61 ENWl Vdd Gnd TG
X575 WL62T WL62 ENWl Vdd Gnd TG
X576 WL63T WL63 ENWl Vdd Gnd TG
X577 WL64T WL64 ENWl Vdd Gnd TG

X599 BL1T BL1 ENBl1 Vdd Gnd TG
X590 BL2T BL2 ENBl2 Vdd Gnd TG
X591 BL3T BL3 ENBl3 Vdd Gnd TG
X592 BL4T BL4 ENBl4 Vdd Gnd TG
X593 BL5T BL5 ENBl5 Vdd Gnd TG
X594 BL6T BL6 ENBl6 Vdd Gnd TG
X595 BL7T BL7 ENBl7 Vdd Gnd TG
X596 BL8T BL8 ENBl8 Vdd Gnd TG

X679 SL1T SL1 ENBl1 Vdd Gnd TG
X680 SL2T SL2 ENBl2 Vdd Gnd TG
X681 SL3T SL3 ENBl3 Vdd Gnd TG
X682 SL4T SL4 ENBl4 Vdd Gnd TG
X683 SL5T SL5 ENBl5 Vdd Gnd TG
X684 SL6T SL6 ENBl6 Vdd Gnd TG
X685 SL7T SL7 ENBl7 Vdd Gnd TG
X686 SL8T SL8 ENBl8 Vdd Gnd TG

* Bitlines Capacitance

Cbl1 BL1 Gnd 'cap'
Cbl2 BL2 Gnd 'cap'
Cbl3 BL3 Gnd 'cap'
Cbl4 BL4 Gnd 'cap'
Cbl5 BL5 Gnd 'cap'
Cbl6 BL6 Gnd 'cap'
Cbl7 BL7 Gnd 'cap'
Cbl8 BL8 Gnd 'cap'

.TRAN 1p 10n

.option rawfmt="psfbin"
