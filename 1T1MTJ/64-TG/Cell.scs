* Crossbar one bit

simulator lang=spice

.include '45nm_LP.pm'
.include 'TRANSGATE.spi'
.include '1T1MBitCell.spi'

.param cap = 1.5f

.param Vvdd = 1.6

.param Vgnd = 0

.param Vread = 0.8

.param TpWord = 0.5n
.param TpWrite = 0.9n
.param TpRead = 0.1n
.param TpPulse = 1n

Vwl1 WL1T Gnd PWL 0 'Vvdd'
Vwl2 WL2T Gnd PWL 0 'Vvdd'
Vwl3 WL3T Gnd PWL 0 'Vvdd'
Vwl4 WL4T Gnd PWL 0 'Vgnd' 'TpPulse-1p' 'Vgnd' 'TpPulse' 'Vvdd' '5n' 'Vvdd' '5n+1p' 'Vgnd'
Vwl5 WL5T Gnd PWL 0 'Vvdd'
Vwl6 WL6T Gnd PWL 0 'Vvdd'
Vwl7 WL7T Gnd PWL 0 'Vvdd'
Vwl8 WL8T Gnd PWL 0 'Vvdd'

Vbl1 BL1T Gnd PWL 0 'Vgnd'
Vbl2 BL2T Gnd PWL 0 'Vgnd'
Vbl3 BL3T Gnd PWL 0 'Vgnd'
Vbl4 BL4T Gnd PWL 0 'Vgnd' '5n+TpWrite-1p' 'Vgnd' '5n+TpWrite' 'Vvdd' '7n-1p' 'Vvdd' '7n' 'Vgnd'
Vbl5 BL5T Gnd PWL 0 'Vgnd'
Vbl6 BL6T Gnd PWL 0 'Vgnd'
Vbl7 BL7T Gnd PWL 0 'Vgnd'
Vbl8 BL8T Gnd PWL 0 'Vgnd'

Vsl1 SL1T Gnd PWL 0 'Vgnd'
Vsl2 SL2T Gnd PWL 0 'Vgnd'
Vsl3 SL3T Gnd PWL 0 'Vgnd'
Vsl4 SL4T Gnd PWL 0 'Vgnd' 'TpRead-1p' 'Vgnd' 'TpRead' 'Vvdd' 'TpRead+TpPulse' 'Vvdd' 'TpRead+TpPulse+1p' 'Vgnd' '8n-1p+TpRead' 'Vgnd' '8n+TpRead' 'Vread' '8n+0.8n' 'Vread' '8n+0.8n+1p' 'Vgnd'
Vsl5 SL5T Gnd PWL 0 'Vgnd'
Vsl6 SL6T Gnd PWL 0 'Vgnd'
Vsl7 SL7T Gnd PWL 0 'Vgnd'
Vsl8 SL8T Gnd PWL 0 'Vgnd'

Vbl1en ENBl1 Gnd PWL 0 'Vgnd'
Vbl2en ENBl2 Gnd PWL 0 'Vgnd'
Vbl3en ENBl3 Gnd PWL 0 'Vgnd'
Vbl4en ENBl4 Gnd PWL 0 'Vvdd'
Vbl5en ENBl5 Gnd PWL 0 'Vgnd'
Vbl6en ENBl6 Gnd PWL 0 'Vgnd'
Vbl7en ENBl7 Gnd PWL 0 'Vgnd'
Vbl8en ENBl8 Gnd PWL 0 'Vgnd'

Vwlen ENWl Gnd PWL 0 'Vgnd'
Vwlen1 ENWl1 Gnd PWL 0 'Vvdd'

Vvdd Vdd Gnd 'Vvdd'

* tristates

X514 WL1T WL1 ENWl Vdd Gnd TG
X515 WL2T WL2 ENWl Vdd Gnd TG
X516 WL3T WL3 ENWl Vdd Gnd TG
X517 WL4T WL4 ENWl Vdd Gnd TG
X518 WL5T WL5 ENWl Vdd Gnd TG
X519 WL6T WL6 ENWl Vdd Gnd TG
X520 WL7T WL7 ENWl Vdd Gnd TG
X521 WL8T WL8 ENWl1 Vdd Gnd TG
X522 WL9T WL9 ENWl Vdd Gnd TG
X523 WL10T WL10 ENWl Vdd Gnd TG
X524 WL11T WL11 ENWl Vdd Gnd TG
X525 WL12T WL12 ENWl Vdd Gnd TG
X526 WL13T WL13 ENWl Vdd Gnd TG
X527 WL14T WL14 ENWl Vdd Gnd TG
X528 WL15T WL15 ENWl Vdd Gnd TG
X529 WL16T WL16 ENWl Vdd Gnd TG

X599 BL1T BL1 ENBl1 Vdd Gnd TG
X590 BL2T BL2 ENBl2 Vdd Gnd TG
X591 BL3T BL3 ENBl3 Vdd Gnd TG
X592 BL4T BL4 ENBl4 Vdd Gnd TG
X593 BL5T BL5 ENBl5 Vdd Gnd TG
X594 BL6T BL6 ENBl6 Vdd Gnd TG
X595 BL7T BL7 ENBl7 Vdd Gnd TG
X596 BL8T BL8 ENBl8 Vdd Gnd TG

X679 SL1T SL1 ENBl1 Vdd Gnd TG
X680 SL2T SL2 ENBl2 Vdd Gnd TG
X681 SL3T SL3 ENBl3 Vdd Gnd TG
X682 SL4T SL4 ENBl4 Vdd Gnd TG
X683 SL5T SL5 ENBl5 Vdd Gnd TG
X684 SL6T SL6 ENBl6 Vdd Gnd TG
X685 SL7T SL7 ENBl7 Vdd Gnd TG
X686 SL8T SL8 ENBl8 Vdd Gnd TG

* Bitcell

X1 NM1 SL1 WL1 BCTM
Vtest1 BL1 NM1 0
X2 NM2 SL1 WL2 BCTM
Vtest2 BL1 NM2 0
X3 NM3 SL1 WL3 BCTM
Vtest3 BL1 NM3 0
X4 NM4 SL1 WL4 BCTM
Vtest4 BL1 NM4 0
X5 NM5 SL1 WL5 BCTM
Vtest5 BL1 NM5 0
X6 NM6 SL1 WL6 BCTM
Vtest6 BL1 NM6 0
X7 NM7 SL1 WL7 BCTM
Vtest7 BL1 NM7 0
X8 NM8 SL1 WL8 BCTM
Vtest8 BL1 NM8 0
X9 NM9 SL2 WL1 BCTM
Vtest9 BL2 NM9 0
X10 NM10 SL2 WL2 BCTM
Vtest10 BL2 NM10 0
X11 NM11 SL2 WL3 BCTM
Vtest11 BL2 NM11 0
X12 NM12 SL2 WL4 BCTM
Vtest12 BL2 NM12 0
X13 NM13 SL2 WL5 BCTM
Vtest13 BL2 NM13 0
X14 NM14 SL2 WL6 BCTM
Vtest14 BL2 NM14 0
X15 NM15 SL2 WL7 BCTM
Vtest15 BL2 NM15 0
X16 NM16 SL2 WL8 BCTM
Vtest16 BL2 NM16 0
X17 NM17 SL3 WL1 BCTM
Vtest17 BL3 NM17 0
X18 NM18 SL3 WL2 BCTM
Vtest18 BL3 NM18 0
X19 NM19 SL3 WL3 BCTM
Vtest19 BL3 NM19 0
X20 NM20 SL3 WL4 BCTM
Vtest20 BL3 NM20 0
X21 NM21 SL3 WL5 BCTM
Vtest21 BL3 NM21 0
X22 NM22 SL3 WL6 BCTM
Vtest22 BL3 NM22 0
X23 NM23 SL3 WL7 BCTM
Vtest23 BL3 NM23 0
X24 NM24 SL3 WL8 BCTM
Vtest24 BL3 NM24 0
X25 NM25 SL4 WL1 BCTM
Vtest25 BL4 NM25 0
X26 NM26 SL4 WL2 BCTM
Vtest26 BL4 NM26 0
X27 NM27 SL4 WL3 BCTM
Vtest27 BL4 NM27 0
X28 NM28 SL4 WL4 BCTM
Vtest28 BL4 NM28 0
X29 NM29 SL4 WL5 BCTM
Vtest29 BL4 NM29 0
X30 NM30 SL4 WL6 BCTM
Vtest30 BL4 NM30 0
X31 NM31 SL4 WL7 BCTM
Vtest31 BL4 NM31 0
X32 NM32 SL4 WL8 BCTM
Vtest32 BL4 NM32 0
X33 NM33 SL5 WL1 BCTM
Vtest33 BL5 NM33 0
X34 NM34 SL5 WL2 BCTM
Vtest34 BL5 NM34 0
X35 NM35 SL5 WL3 BCTM
Vtest35 BL5 NM35 0
X36 NM36 SL5 WL4 BCTM
Vtest36 BL5 NM36 0
X37 NM37 SL5 WL5 BCTM
Vtest37 BL5 NM37 0
X38 NM38 SL5 WL6 BCTM
Vtest38 BL5 NM38 0
X39 NM39 SL5 WL7 BCTM
Vtest39 BL5 NM39 0
X40 NM40 SL5 WL8 BCTM
Vtest40 BL5 NM40 0
X41 NM41 SL6 WL1 BCTM
Vtest41 BL6 NM41 0
X42 NM42 SL6 WL2 BCTM
Vtest42 BL6 NM42 0
X43 NM43 SL6 WL3 BCTM
Vtest43 BL6 NM43 0
X44 NM44 SL6 WL4 BCTM
Vtest44 BL6 NM44 0
X45 NM45 SL6 WL5 BCTM
Vtest45 BL6 NM45 0
X46 NM46 SL6 WL6 BCTM
Vtest46 BL6 NM46 0
X47 NM47 SL6 WL7 BCTM
Vtest47 BL6 NM47 0
X48 NM48 SL6 WL8 BCTM
Vtest48 BL6 NM48 0
X49 NM49 SL7 WL1 BCTM
Vtest49 BL7 NM49 0
X50 NM50 SL7 WL2 BCTM
Vtest50 BL7 NM50 0
X51 NM51 SL7 WL3 BCTM
Vtest51 BL7 NM51 0
X52 NM52 SL7 WL4 BCTM
Vtest52 BL7 NM52 0
X53 NM53 SL7 WL5 BCTM
Vtest53 BL7 NM53 0
X54 NM54 SL7 WL6 BCTM
Vtest54 BL7 NM54 0
X55 NM55 SL7 WL7 BCTM
Vtest55 BL7 NM55 0
X56 NM56 SL7 WL8 BCTM
Vtest56 BL7 NM56 0
X57 NM57 SL8 WL1 BCTM
Vtest57 BL8 NM57 0
X58 NM58 SL8 WL2 BCTM
Vtest58 BL8 NM58 0
X59 NM59 SL8 WL3 BCTM
Vtest59 BL8 NM59 0
X60 NM60 SL8 WL4 BCTM
Vtest60 BL8 NM60 0
X61 NM61 SL8 WL5 BCTM
Vtest61 BL8 NM61 0
X62 NM62 SL8 WL6 BCTM
Vtest62 BL8 NM62 0
X63 NM63 SL8 WL7 BCTM
Vtest63 BL8 NM63 0
X64 NM64 SL8 WL8 BCTM
Vtest64 BL8 NM64 0

* Bitlines Capacitance

Cbl1 BL1 Gnd 'cap'
Cbl2 BL2 Gnd 'cap'
Cbl3 BL3 Gnd 'cap'
Cbl4 BL4 Gnd 'cap'
Cbl5 BL5 Gnd 'cap'
Cbl6 BL6 Gnd 'cap'
Cbl7 BL7 Gnd 'cap'
Cbl8 BL8 Gnd 'cap'

.TRAN 1p 10n

.option rawfmt="psfbin"
