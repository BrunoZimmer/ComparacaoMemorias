* SRAM memory core

simulator lang=spice

.include '45nm_LP.pm'
.include '6TBitCell.spi'
.include 'TRISTATE.spi'
.include 'PreCharge.spi'
.include 'PassTransistor.spi'

.param VPre = 1
.param TpEn = 0.5n
.param TpWl = 1n
.param cap = 15f

Vwl1 WL1 Gnd PWL 0 0
Vwl2 WL2 Gnd PWL 0 0
Vwl3 WL3 Gnd PWL 0 0
Vwl4 WL4 Gnd PWL 0 0
Vwl5 WL5 Gnd PWL 0 0
Vwl6 WL6 Gnd PWL 0 0
Vwl7 WL7 Gnd PWL 0 0
Vwl8 WL8 Gnd PWL 0 0 '(TpWl)' 0 '(TpWl+1p)' 1 (1.5n+2p) 1 (1.5n+3p) 0
Vwl9 WL9 Gnd PWL 0 0
Vwl10 WL10 Gnd PWL 0 0
Vwl11 WL11 Gnd PWL 0 0
Vwl12 WL12 Gnd PWL 0 0
Vwl13 WL13 Gnd PWL 0 0
Vwl14 WL14 Gnd PWL 0 0
Vwl15 WL15 Gnd PWL 0 0
Vwl16 WL16 Gnd PWL 0 0

Vwd1 WD1 Gnd 0
Vwd2 WD2 Gnd 0
Vwd3 WD3 Gnd 0
Vwd4 WD4 Gnd 0
Vwd5 WD5 Gnd 0
Vwd6 WD6 Gnd 0
Vwd7 WD7 Gnd 0
Vwd8 WD8 Gnd 0

Vwdb1 WDB1 Gnd 1
Vwdb2 WDB2 Gnd 1
Vwdb3 WDB3 Gnd 1
Vwdb4 WDB4 Gnd 1
Vwdb5 WDB5 Gnd 1
Vwdb6 WDB6 Gnd 1
Vwdb7 WDB7 Gnd 1
Vwdb8 WDB8 Gnd 1

Ven1 EN1 Gnd 0
Ven2 EN2 Gnd 0
Ven3 EN3 Gnd 0
Ven4 EN4 Gnd PWL 0 0 '(TpEn-1p)' 0 'TpEn' 1 1.5n 1 (1.5n+1p) 0
Ven5 EN5 Gnd 0
Ven6 EN6 Gnd 0
Ven7 EN7 Gnd 0
Ven8 EN8 Gnd 0

Venb1 ENB1 Gnd 1
Venb2 ENB2 Gnd 1
Venb3 ENB3 Gnd 1
Venb4 ENB4 Gnd  PWL 0 1 '(TpEn-1p)' 1 'TpEn' 0 1.5n 0 (1.5n+1p) 1
Venb5 ENB5 Gnd 1
Venb6 ENB6 Gnd 1
Venb7 ENB7 Gnd 1
Venb8 ENB8 Gnd 1

Vpre1 PRE1 Gnd 1
Vpre2 PRE2 Gnd 1
Vpre3 PRE3 Gnd 1
Vpre4 PRE4 Gnd 1
Vpre5 PRE5 Gnd 1
Vpre6 PRE6 Gnd 1
Vpre7 PRE7 Gnd 1
Vpre8 PRE8 Gnd 1

Vvdd Vvdd Gnd 1
Vdd Vdd Gnd 1
Vgnd Gnd 0 0
* Bitcell

X1 NM1 BLB1 WL1 Vdd Gnd BC
Vtest1 BL1 NM1 0

X2 NM2 BLB1 WL2 Vdd Gnd BC
Vtest2 BL1 NM2 0

X3 NM3 BLB1 WL3 Vdd Gnd BC
Vtest3 BL1 NM3 0

X4 NM4 BLB1 WL4 Vdd Gnd BC
Vtest4 BL1 NM4 0

X5 NM5 BLB1 WL5 Vdd Gnd BC
Vtest5 BL1 NM5 0

X6 NM6 BLB1 WL6 Vdd Gnd BC
Vtest6 BL1 NM6 0

X7 NM7 BLB1 WL7 Vdd Gnd BC
Vtest7 BL1 NM7 0

X8 NM8 BLB1 WL8 Vdd Gnd BC
Vtest8 BL1 NM8 0

X9 NM9 BLB1 WL9 Vdd Gnd BC
Vtest9 BL1 NM9 0

X10 NM10 BLB1 WL10 Vdd Gnd BC
Vtest10 BL1 NM10 0

X11 NM11 BLB1 WL11 Vdd Gnd BC
Vtest11 BL1 NM11 0

X12 NM12 BLB1 WL12 Vdd Gnd BC
Vtest12 BL1 NM12 0

X13 NM13 BLB1 WL13 Vdd Gnd BC
Vtest13 BL1 NM13 0

X14 NM14 BLB1 WL14 Vdd Gnd BC
Vtest14 BL1 NM14 0

X15 NM15 BLB1 WL15 Vdd Gnd BC
Vtest15 BL1 NM15 0

X16 NM16 BLB1 WL16 Vdd Gnd BC
Vtest16 BL1 NM16 0

X17 NM17 BLB2 WL1 Vdd Gnd BC
Vtest17 BL2 NM17 0

X18 NM18 BLB2 WL2 Vdd Gnd BC
Vtest18 BL2 NM18 0

X19 NM19 BLB2 WL3 Vdd Gnd BC
Vtest19 BL2 NM19 0

X20 NM20 BLB2 WL4 Vdd Gnd BC
Vtest20 BL2 NM20 0

X21 NM21 BLB2 WL5 Vdd Gnd BC
Vtest21 BL2 NM21 0

X22 NM22 BLB2 WL6 Vdd Gnd BC
Vtest22 BL2 NM22 0

X23 NM23 BLB2 WL7 Vdd Gnd BC
Vtest23 BL2 NM23 0

X24 NM24 BLB2 WL8 Vdd Gnd BC
Vtest24 BL2 NM24 0

X25 NM25 BLB2 WL9 Vdd Gnd BC
Vtest25 BL2 NM25 0

X26 NM26 BLB2 WL10 Vdd Gnd BC
Vtest26 BL2 NM26 0

X27 NM27 BLB2 WL11 Vdd Gnd BC
Vtest27 BL2 NM27 0

X28 NM28 BLB2 WL12 Vdd Gnd BC
Vtest28 BL2 NM28 0

X29 NM29 BLB2 WL13 Vdd Gnd BC
Vtest29 BL2 NM29 0

X30 NM30 BLB2 WL14 Vdd Gnd BC
Vtest30 BL2 NM30 0

X31 NM31 BLB2 WL15 Vdd Gnd BC
Vtest31 BL2 NM31 0

X32 NM32 BLB2 WL16 Vdd Gnd BC
Vtest32 BL2 NM32 0

X33 NM33 BLB3 WL1 Vdd Gnd BC
Vtest33 BL3 NM33 0

X34 NM34 BLB3 WL2 Vdd Gnd BC
Vtest34 BL3 NM34 0

X35 NM35 BLB3 WL3 Vdd Gnd BC
Vtest35 BL3 NM35 0

X36 NM36 BLB3 WL4 Vdd Gnd BC
Vtest36 BL3 NM36 0

X37 NM37 BLB3 WL5 Vdd Gnd BC
Vtest37 BL3 NM37 0

X38 NM38 BLB3 WL6 Vdd Gnd BC
Vtest38 BL3 NM38 0

X39 NM39 BLB3 WL7 Vdd Gnd BC
Vtest39 BL3 NM39 0

X40 NM40 BLB3 WL8 Vdd Gnd BC
Vtest40 BL3 NM40 0

X41 NM41 BLB3 WL9 Vdd Gnd BC
Vtest41 BL3 NM41 0

X42 NM42 BLB3 WL10 Vdd Gnd BC
Vtest42 BL3 NM42 0

X43 NM43 BLB3 WL11 Vdd Gnd BC
Vtest43 BL3 NM43 0

X44 NM44 BLB3 WL12 Vdd Gnd BC
Vtest44 BL3 NM44 0

X45 NM45 BLB3 WL13 Vdd Gnd BC
Vtest45 BL3 NM45 0

X46 NM46 BLB3 WL14 Vdd Gnd BC
Vtest46 BL3 NM46 0

X47 NM47 BLB3 WL15 Vdd Gnd BC
Vtest47 BL3 NM47 0

X48 NM48 BLB3 WL16 Vdd Gnd BC
Vtest48 BL3 NM48 0

X49 NM49 BLB4 WL1 Vdd Gnd BC
Vtest49 BL4 NM49 0

X50 NM50 BLB4 WL2 Vdd Gnd BC
Vtest50 BL4 NM50 0

X51 NM51 BLB4 WL3 Vdd Gnd BC
Vtest51 BL4 NM51 0

X52 NM52 BLB4 WL4 Vdd Gnd BC
Vtest52 BL4 NM52 0

X53 NM53 BLB4 WL5 Vdd Gnd BC
Vtest53 BL4 NM53 0

X54 NM54 BLB4 WL6 Vdd Gnd BC
Vtest54 BL4 NM54 0

X55 NM55 BLB4 WL7 Vdd Gnd BC
Vtest55 BL4 NM55 0

X56 NM56 BLB4 WL8 Vdd Gnd BC
Vtest56 BL4 NM56 0

X57 NM57 BLB4 WL9 Vdd Gnd BC
Vtest57 BL4 NM57 0

X58 NM58 BLB4 WL10 Vdd Gnd BC
Vtest58 BL4 NM58 0

X59 NM59 BLB4 WL11 Vdd Gnd BC
Vtest59 BL4 NM59 0

X60 NM60 BLB4 WL12 Vdd Gnd BC
Vtest60 BL4 NM60 0

X61 NM61 BLB4 WL13 Vdd Gnd BC
Vtest61 BL4 NM61 0

X62 NM62 BLB4 WL14 Vdd Gnd BC
Vtest62 BL4 NM62 0

X63 NM63 BLB4 WL15 Vdd Gnd BC
Vtest63 BL4 NM63 0

X64 NM64 BLB4 WL16 Vdd Gnd BC
Vtest64 BL4 NM64 0

X65 NM65 BLB5 WL1 Vdd Gnd BC
Vtest65 BL5 NM65 0

X66 NM66 BLB5 WL2 Vdd Gnd BC
Vtest66 BL5 NM66 0

X67 NM67 BLB5 WL3 Vdd Gnd BC
Vtest67 BL5 NM67 0

X68 NM68 BLB5 WL4 Vdd Gnd BC
Vtest68 BL5 NM68 0

X69 NM69 BLB5 WL5 Vdd Gnd BC
Vtest69 BL5 NM69 0

X70 NM70 BLB5 WL6 Vdd Gnd BC
Vtest70 BL5 NM70 0

X71 NM71 BLB5 WL7 Vdd Gnd BC
Vtest71 BL5 NM71 0

X72 NM72 BLB5 WL8 Vdd Gnd BC
Vtest72 BL5 NM72 0

X73 NM73 BLB5 WL9 Vdd Gnd BC
Vtest73 BL5 NM73 0

X74 NM74 BLB5 WL10 Vdd Gnd BC
Vtest74 BL5 NM74 0

X75 NM75 BLB5 WL11 Vdd Gnd BC
Vtest75 BL5 NM75 0

X76 NM76 BLB5 WL12 Vdd Gnd BC
Vtest76 BL5 NM76 0

X77 NM77 BLB5 WL13 Vdd Gnd BC
Vtest77 BL5 NM77 0

X78 NM78 BLB5 WL14 Vdd Gnd BC
Vtest78 BL5 NM78 0

X79 NM79 BLB5 WL15 Vdd Gnd BC
Vtest79 BL5 NM79 0

X80 NM80 BLB5 WL16 Vdd Gnd BC
Vtest80 BL5 NM80 0

X81 NM81 BLB6 WL1 Vdd Gnd BC
Vtest81 BL6 NM81 0

X82 NM82 BLB6 WL2 Vdd Gnd BC
Vtest82 BL6 NM82 0

X83 NM83 BLB6 WL3 Vdd Gnd BC
Vtest83 BL6 NM83 0

X84 NM84 BLB6 WL4 Vdd Gnd BC
Vtest84 BL6 NM84 0

X85 NM85 BLB6 WL5 Vdd Gnd BC
Vtest85 BL6 NM85 0

X86 NM86 BLB6 WL6 Vdd Gnd BC
Vtest86 BL6 NM86 0

X87 NM87 BLB6 WL7 Vdd Gnd BC
Vtest87 BL6 NM87 0

X88 NM88 BLB6 WL8 Vdd Gnd BC
Vtest88 BL6 NM88 0

X89 NM89 BLB6 WL9 Vdd Gnd BC
Vtest89 BL6 NM89 0

X90 NM90 BLB6 WL10 Vdd Gnd BC
Vtest90 BL6 NM90 0

X91 NM91 BLB6 WL11 Vdd Gnd BC
Vtest91 BL6 NM91 0

X92 NM92 BLB6 WL12 Vdd Gnd BC
Vtest92 BL6 NM92 0

X93 NM93 BLB6 WL13 Vdd Gnd BC
Vtest93 BL6 NM93 0

X94 NM94 BLB6 WL14 Vdd Gnd BC
Vtest94 BL6 NM94 0

X95 NM95 BLB6 WL15 Vdd Gnd BC
Vtest95 BL6 NM95 0

X96 NM96 BLB6 WL16 Vdd Gnd BC
Vtest96 BL6 NM96 0

X97 NM97 BLB7 WL1 Vdd Gnd BC
Vtest97 BL7 NM97 0

X98 NM98 BLB7 WL2 Vdd Gnd BC
Vtest98 BL7 NM98 0

X99 NM99 BLB7 WL3 Vdd Gnd BC
Vtest99 BL7 NM99 0

X100 NM100 BLB7 WL4 Vdd Gnd BC
Vtest100 BL7 NM100 0

X101 NM101 BLB7 WL5 Vdd Gnd BC
Vtest101 BL7 NM101 0

X102 NM102 BLB7 WL6 Vdd Gnd BC
Vtest102 BL7 NM102 0

X103 NM103 BLB7 WL7 Vdd Gnd BC
Vtest103 BL7 NM103 0

X104 NM104 BLB7 WL8 Vdd Gnd BC
Vtest104 BL7 NM104 0

X105 NM105 BLB7 WL9 Vdd Gnd BC
Vtest105 BL7 NM105 0

X106 NM106 BLB7 WL10 Vdd Gnd BC
Vtest106 BL7 NM106 0

X107 NM107 BLB7 WL11 Vdd Gnd BC
Vtest107 BL7 NM107 0

X108 NM108 BLB7 WL12 Vdd Gnd BC
Vtest108 BL7 NM108 0

X109 NM109 BLB7 WL13 Vdd Gnd BC
Vtest109 BL7 NM109 0

X110 NM110 BLB7 WL14 Vdd Gnd BC
Vtest110 BL7 NM110 0

X111 NM111 BLB7 WL15 Vdd Gnd BC
Vtest111 BL7 NM111 0

X112 NM112 BLB7 WL16 Vdd Gnd BC
Vtest112 BL7 NM112 0

X113 NM113 BLB8 WL1 Vdd Gnd BC
Vtest113 BL8 NM113 0

X114 NM114 BLB8 WL2 Vdd Gnd BC
Vtest114 BL8 NM114 0

X115 NM115 BLB8 WL3 Vdd Gnd BC
Vtest115 BL8 NM115 0

X116 NM116 BLB8 WL4 Vdd Gnd BC
Vtest116 BL8 NM116 0

X117 NM117 BLB8 WL5 Vdd Gnd BC
Vtest117 BL8 NM117 0

X118 NM118 BLB8 WL6 Vdd Gnd BC
Vtest118 BL8 NM118 0

X119 NM119 BLB8 WL7 Vdd Gnd BC
Vtest119 BL8 NM119 0

X120 NM120 BLB8 WL8 Vdd Gnd BC
Vtest120 BL8 NM120 0

X121 NM121 BLB8 WL9 Vdd Gnd BC
Vtest121 BL8 NM121 0

X122 NM122 BLB8 WL10 Vdd Gnd BC
Vtest122 BL8 NM122 0

X123 NM123 BLB8 WL11 Vdd Gnd BC
Vtest123 BL8 NM123 0

X124 NM124 BLB8 WL12 Vdd Gnd BC
Vtest124 BL8 NM124 0

X125 NM125 BLB8 WL13 Vdd Gnd BC
Vtest125 BL8 NM125 0

X126 NM126 BLB8 WL14 Vdd Gnd BC
Vtest126 BL8 NM126 0

X127 NM127 BLB8 WL15 Vdd Gnd BC
Vtest127 BL8 NM127 0

X128 NM128 BLB8 WL16 Vdd Gnd BC
Vtest128 BL8 NM128 0

* Write Driver

X129 WD1 BL1 EN1 ENB1 Vdd Gnd TI
X130 WD2 BL2 EN2 ENB2 Vdd Gnd TI
X131 WD3 BL3 EN3 ENB3 Vdd Gnd TI
X132 WD4 BL4 EN4 ENB4 Vdd Gnd TI
X133 WD5 BL5 EN5 ENB5 Vdd Gnd TI
X134 WD6 BL6 EN6 ENB6 Vdd Gnd TI
X135 WD7 BL7 EN7 ENB7 Vdd Gnd TI
X136 WD8 BL8 EN8 ENB8 Vdd Gnd TI

X145 WDB1 BLB1 EN1 ENB1 Vdd Gnd TI
X146 WDB2 BLB2 EN2 ENB2 Vdd Gnd TI
X147 WDB3 BLB3 EN3 ENB3 Vdd Gnd TI
X148 WDB4 BLB4 EN4 ENB4 Vdd Gnd TI
X149 WDB5 BLB5 EN5 ENB5 Vdd Gnd TI
X150 WDB6 BLB6 EN6 ENB6 Vdd Gnd TI
X151 WDB7 BLB7 EN7 ENB7 Vdd Gnd TI
X152 WDB8 BLB8 EN8 ENB8 Vdd Gnd TI

* Pre charge

X161 BL1 BLB1 PRE1 Vdd PC
X162 BL2 BLB2 PRE2 Vdd PC
X163 BL3 BLB3 PRE3 Vdd PC
X164 BL4 BLB4 PRE4 Vdd PC
X165 BL5 BLB5 PRE5 Vdd PC
X166 BL6 BLB6 PRE6 Vdd PC
X167 BL7 BLB7 PRE7 Vdd PC
X168 BL8 BLB8 PRE8 Vdd PC

* Bitlines Capacitance

Cbl1 BL1 Gnd 'cap'
Cbl2 BL2 Gnd 'cap'
Cbl3 BL3 Gnd 'cap'
Cbl4 BL4 Gnd 'cap'
Cbl5 BL5 Gnd 'cap'
Cbl6 BL6 Gnd 'cap'
Cbl7 BL7 Gnd 'cap'
Cbl8 BL8 Gnd 'cap'
Cblb1 BLB1 Gnd 'cap'
Cblb2 BLB2 Gnd 'cap'
Cblb3 BLB3 Gnd 'cap'
Cblb4 BLB4 Gnd 'cap'
Cblb5 BLB5 Gnd 'cap'
Cblb6 BLB6 Gnd 'cap'
Cblb7 BLB7 Gnd 'cap'
Cblb8 BLB8 Gnd 'cap'

.TRAN 1p 10n

.option rawfmt="psfbin"

.IC V(X56.Q)=0 V(X56.QB)=1 V(BL4)=1 V(BLB4)=1
