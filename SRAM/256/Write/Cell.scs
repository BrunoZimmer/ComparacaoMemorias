* SRAM memory core

simulator lang=spice

.include '45nm_LP.pm'
.include '6TBitCell.spi'
.include 'TRISTATE.spi'
.include 'PreCharge.spi'
.include 'PassTransistor.spi'

.param VPre = 1
.param TpEn = 0.5n
.param TpWl = 1n
.param cap = 15f

Vwl1 WL1 Gnd PWL 0 0
Vwl2 WL2 Gnd PWL 0 0
Vwl3 WL3 Gnd PWL 0 0
Vwl4 WL4 Gnd PWL 0 0
Vwl5 WL5 Gnd PWL 0 0
Vwl6 WL6 Gnd PWL 0 0
Vwl7 WL7 Gnd PWL 0 0
Vwl8 WL8 Gnd PWL 0 0
Vwl9 WL9 Gnd PWL 0 0
Vwl10 WL10 Gnd PWL 0 0
Vwl11 WL11 Gnd PWL 0 0
Vwl12 WL12 Gnd PWL 0 0
Vwl13 WL13 Gnd PWL 0 0
Vwl14 WL14 Gnd PWL 0 0
Vwl15 WL15 Gnd PWL 0 0
Vwl16 WL16 Gnd PWL 0 0 '(TpWl)' 0 '(TpWl+1p)' 1 (1.5n+2p) 1 (1.5n+3p) 0
Vwl17 WL17 Gnd PWL 0 0
Vwl18 WL18 Gnd PWL 0 0
Vwl19 WL19 Gnd PWL 0 0
Vwl20 WL20 Gnd PWL 0 0
Vwl21 WL21 Gnd PWL 0 0
Vwl22 WL22 Gnd PWL 0 0
Vwl23 WL23 Gnd PWL 0 0
Vwl24 WL24 Gnd PWL 0 0
Vwl25 WL25 Gnd PWL 0 0
Vwl26 WL26 Gnd PWL 0 0
Vwl27 WL27 Gnd PWL 0 0
Vwl28 WL28 Gnd PWL 0 0
Vwl29 WL29 Gnd PWL 0 0
Vwl30 WL30 Gnd PWL 0 0
Vwl31 WL31 Gnd PWL 0 0
Vwl32 WL32 Gnd PWL 0 0

Vwd1 WD1 Gnd 0
Vwd2 WD2 Gnd 0
Vwd3 WD3 Gnd 0
Vwd4 WD4 Gnd 0
Vwd5 WD5 Gnd 0
Vwd6 WD6 Gnd 0
Vwd7 WD7 Gnd 0
Vwd8 WD8 Gnd 0

Vwdb1 WDB1 Gnd 1
Vwdb2 WDB2 Gnd 1
Vwdb3 WDB3 Gnd 1
Vwdb4 WDB4 Gnd 1
Vwdb5 WDB5 Gnd 1
Vwdb6 WDB6 Gnd 1
Vwdb7 WDB7 Gnd 1
Vwdb8 WDB8 Gnd 1

Ven1 EN1 Gnd 0
Ven2 EN2 Gnd 0
Ven3 EN3 Gnd 0
Ven4 EN4 Gnd PWL 0 0 '(TpEn-1p)' 0 'TpEn' 1 1.5n 1 (1.5n+1p) 0
Ven5 EN5 Gnd 0
Ven6 EN6 Gnd 0
Ven7 EN7 Gnd 0
Ven8 EN8 Gnd 0

Venb1 ENB1 Gnd 1
Venb2 ENB2 Gnd 1
Venb3 ENB3 Gnd 1
Venb4 ENB4 Gnd  PWL 0 1 '(TpEn-1p)' 1 'TpEn' 0 1.5n 0 (1.5n+1p) 1
Venb5 ENB5 Gnd 1
Venb6 ENB6 Gnd 1
Venb7 ENB7 Gnd 1
Venb8 ENB8 Gnd 1

Vpre1 PRE1 Gnd 1
Vpre2 PRE2 Gnd 1
Vpre3 PRE3 Gnd 1
Vpre4 PRE4 Gnd 1
Vpre5 PRE5 Gnd 1
Vpre6 PRE6 Gnd 1
Vpre7 PRE7 Gnd 1
Vpre8 PRE8 Gnd 1

Vvdd Vvdd Gnd 1
Vdd Vdd Gnd 1
Vgnd Gnd 0 0
* Bitcell

X1 NM1 BLB1 WL1 Vdd Gnd BC
Vtest1 BL1 NM1 0

X2 NM2 BLB1 WL2 Vdd Gnd BC
Vtest2 BL1 NM2 0

X3 NM3 BLB1 WL3 Vdd Gnd BC
Vtest3 BL1 NM3 0

X4 NM4 BLB1 WL4 Vdd Gnd BC
Vtest4 BL1 NM4 0

X5 NM5 BLB1 WL5 Vdd Gnd BC
Vtest5 BL1 NM5 0

X6 NM6 BLB1 WL6 Vdd Gnd BC
Vtest6 BL1 NM6 0

X7 NM7 BLB1 WL7 Vdd Gnd BC
Vtest7 BL1 NM7 0

X8 NM8 BLB1 WL8 Vdd Gnd BC
Vtest8 BL1 NM8 0

X9 NM9 BLB1 WL9 Vdd Gnd BC
Vtest9 BL1 NM9 0

X10 NM10 BLB1 WL10 Vdd Gnd BC
Vtest10 BL1 NM10 0

X11 NM11 BLB1 WL11 Vdd Gnd BC
Vtest11 BL1 NM11 0

X12 NM12 BLB1 WL12 Vdd Gnd BC
Vtest12 BL1 NM12 0

X13 NM13 BLB1 WL13 Vdd Gnd BC
Vtest13 BL1 NM13 0

X14 NM14 BLB1 WL14 Vdd Gnd BC
Vtest14 BL1 NM14 0

X15 NM15 BLB1 WL15 Vdd Gnd BC
Vtest15 BL1 NM15 0

X16 NM16 BLB1 WL16 Vdd Gnd BC
Vtest16 BL1 NM16 0

X17 NM17 BLB1 WL17 Vdd Gnd BC
Vtest17 BL1 NM17 0

X18 NM18 BLB1 WL18 Vdd Gnd BC
Vtest18 BL1 NM18 0

X19 NM19 BLB1 WL19 Vdd Gnd BC
Vtest19 BL1 NM19 0

X20 NM20 BLB1 WL20 Vdd Gnd BC
Vtest20 BL1 NM20 0

X21 NM21 BLB1 WL21 Vdd Gnd BC
Vtest21 BL1 NM21 0

X22 NM22 BLB1 WL22 Vdd Gnd BC
Vtest22 BL1 NM22 0

X23 NM23 BLB1 WL23 Vdd Gnd BC
Vtest23 BL1 NM23 0

X24 NM24 BLB1 WL24 Vdd Gnd BC
Vtest24 BL1 NM24 0

X25 NM25 BLB1 WL25 Vdd Gnd BC
Vtest25 BL1 NM25 0

X26 NM26 BLB1 WL26 Vdd Gnd BC
Vtest26 BL1 NM26 0

X27 NM27 BLB1 WL27 Vdd Gnd BC
Vtest27 BL1 NM27 0

X28 NM28 BLB1 WL28 Vdd Gnd BC
Vtest28 BL1 NM28 0

X29 NM29 BLB1 WL29 Vdd Gnd BC
Vtest29 BL1 NM29 0

X30 NM30 BLB1 WL30 Vdd Gnd BC
Vtest30 BL1 NM30 0

X31 NM31 BLB1 WL31 Vdd Gnd BC
Vtest31 BL1 NM31 0

X32 NM32 BLB1 WL32 Vdd Gnd BC
Vtest32 BL1 NM32 0

X33 NM33 BLB2 WL1 Vdd Gnd BC
Vtest33 BL2 NM33 0

X34 NM34 BLB2 WL2 Vdd Gnd BC
Vtest34 BL2 NM34 0

X35 NM35 BLB2 WL3 Vdd Gnd BC
Vtest35 BL2 NM35 0

X36 NM36 BLB2 WL4 Vdd Gnd BC
Vtest36 BL2 NM36 0

X37 NM37 BLB2 WL5 Vdd Gnd BC
Vtest37 BL2 NM37 0

X38 NM38 BLB2 WL6 Vdd Gnd BC
Vtest38 BL2 NM38 0

X39 NM39 BLB2 WL7 Vdd Gnd BC
Vtest39 BL2 NM39 0

X40 NM40 BLB2 WL8 Vdd Gnd BC
Vtest40 BL2 NM40 0

X41 NM41 BLB2 WL9 Vdd Gnd BC
Vtest41 BL2 NM41 0

X42 NM42 BLB2 WL10 Vdd Gnd BC
Vtest42 BL2 NM42 0

X43 NM43 BLB2 WL11 Vdd Gnd BC
Vtest43 BL2 NM43 0

X44 NM44 BLB2 WL12 Vdd Gnd BC
Vtest44 BL2 NM44 0

X45 NM45 BLB2 WL13 Vdd Gnd BC
Vtest45 BL2 NM45 0

X46 NM46 BLB2 WL14 Vdd Gnd BC
Vtest46 BL2 NM46 0

X47 NM47 BLB2 WL15 Vdd Gnd BC
Vtest47 BL2 NM47 0

X48 NM48 BLB2 WL16 Vdd Gnd BC
Vtest48 BL2 NM48 0

X49 NM49 BLB2 WL17 Vdd Gnd BC
Vtest49 BL2 NM49 0

X50 NM50 BLB2 WL18 Vdd Gnd BC
Vtest50 BL2 NM50 0

X51 NM51 BLB2 WL19 Vdd Gnd BC
Vtest51 BL2 NM51 0

X52 NM52 BLB2 WL20 Vdd Gnd BC
Vtest52 BL2 NM52 0

X53 NM53 BLB2 WL21 Vdd Gnd BC
Vtest53 BL2 NM53 0

X54 NM54 BLB2 WL22 Vdd Gnd BC
Vtest54 BL2 NM54 0

X55 NM55 BLB2 WL23 Vdd Gnd BC
Vtest55 BL2 NM55 0

X56 NM56 BLB2 WL24 Vdd Gnd BC
Vtest56 BL2 NM56 0

X57 NM57 BLB2 WL25 Vdd Gnd BC
Vtest57 BL2 NM57 0

X58 NM58 BLB2 WL26 Vdd Gnd BC
Vtest58 BL2 NM58 0

X59 NM59 BLB2 WL27 Vdd Gnd BC
Vtest59 BL2 NM59 0

X60 NM60 BLB2 WL28 Vdd Gnd BC
Vtest60 BL2 NM60 0

X61 NM61 BLB2 WL29 Vdd Gnd BC
Vtest61 BL2 NM61 0

X62 NM62 BLB2 WL30 Vdd Gnd BC
Vtest62 BL2 NM62 0

X63 NM63 BLB2 WL31 Vdd Gnd BC
Vtest63 BL2 NM63 0

X64 NM64 BLB2 WL32 Vdd Gnd BC
Vtest64 BL2 NM64 0

X65 NM65 BLB3 WL1 Vdd Gnd BC
Vtest65 BL3 NM65 0

X66 NM66 BLB3 WL2 Vdd Gnd BC
Vtest66 BL3 NM66 0

X67 NM67 BLB3 WL3 Vdd Gnd BC
Vtest67 BL3 NM67 0

X68 NM68 BLB3 WL4 Vdd Gnd BC
Vtest68 BL3 NM68 0

X69 NM69 BLB3 WL5 Vdd Gnd BC
Vtest69 BL3 NM69 0

X70 NM70 BLB3 WL6 Vdd Gnd BC
Vtest70 BL3 NM70 0

X71 NM71 BLB3 WL7 Vdd Gnd BC
Vtest71 BL3 NM71 0

X72 NM72 BLB3 WL8 Vdd Gnd BC
Vtest72 BL3 NM72 0

X73 NM73 BLB3 WL9 Vdd Gnd BC
Vtest73 BL3 NM73 0

X74 NM74 BLB3 WL10 Vdd Gnd BC
Vtest74 BL3 NM74 0

X75 NM75 BLB3 WL11 Vdd Gnd BC
Vtest75 BL3 NM75 0

X76 NM76 BLB3 WL12 Vdd Gnd BC
Vtest76 BL3 NM76 0

X77 NM77 BLB3 WL13 Vdd Gnd BC
Vtest77 BL3 NM77 0

X78 NM78 BLB3 WL14 Vdd Gnd BC
Vtest78 BL3 NM78 0

X79 NM79 BLB3 WL15 Vdd Gnd BC
Vtest79 BL3 NM79 0

X80 NM80 BLB3 WL16 Vdd Gnd BC
Vtest80 BL3 NM80 0

X81 NM81 BLB3 WL17 Vdd Gnd BC
Vtest81 BL3 NM81 0

X82 NM82 BLB3 WL18 Vdd Gnd BC
Vtest82 BL3 NM82 0

X83 NM83 BLB3 WL19 Vdd Gnd BC
Vtest83 BL3 NM83 0

X84 NM84 BLB3 WL20 Vdd Gnd BC
Vtest84 BL3 NM84 0

X85 NM85 BLB3 WL21 Vdd Gnd BC
Vtest85 BL3 NM85 0

X86 NM86 BLB3 WL22 Vdd Gnd BC
Vtest86 BL3 NM86 0

X87 NM87 BLB3 WL23 Vdd Gnd BC
Vtest87 BL3 NM87 0

X88 NM88 BLB3 WL24 Vdd Gnd BC
Vtest88 BL3 NM88 0

X89 NM89 BLB3 WL25 Vdd Gnd BC
Vtest89 BL3 NM89 0

X90 NM90 BLB3 WL26 Vdd Gnd BC
Vtest90 BL3 NM90 0

X91 NM91 BLB3 WL27 Vdd Gnd BC
Vtest91 BL3 NM91 0

X92 NM92 BLB3 WL28 Vdd Gnd BC
Vtest92 BL3 NM92 0

X93 NM93 BLB3 WL29 Vdd Gnd BC
Vtest93 BL3 NM93 0

X94 NM94 BLB3 WL30 Vdd Gnd BC
Vtest94 BL3 NM94 0

X95 NM95 BLB3 WL31 Vdd Gnd BC
Vtest95 BL3 NM95 0

X96 NM96 BLB3 WL32 Vdd Gnd BC
Vtest96 BL3 NM96 0

X97 NM97 BLB4 WL1 Vdd Gnd BC
Vtest97 BL4 NM97 0

X98 NM98 BLB4 WL2 Vdd Gnd BC
Vtest98 BL4 NM98 0

X99 NM99 BLB4 WL3 Vdd Gnd BC
Vtest99 BL4 NM99 0

X100 NM100 BLB4 WL4 Vdd Gnd BC
Vtest100 BL4 NM100 0

X101 NM101 BLB4 WL5 Vdd Gnd BC
Vtest101 BL4 NM101 0

X102 NM102 BLB4 WL6 Vdd Gnd BC
Vtest102 BL4 NM102 0

X103 NM103 BLB4 WL7 Vdd Gnd BC
Vtest103 BL4 NM103 0

X104 NM104 BLB4 WL8 Vdd Gnd BC
Vtest104 BL4 NM104 0

X105 NM105 BLB4 WL9 Vdd Gnd BC
Vtest105 BL4 NM105 0

X106 NM106 BLB4 WL10 Vdd Gnd BC
Vtest106 BL4 NM106 0

X107 NM107 BLB4 WL11 Vdd Gnd BC
Vtest107 BL4 NM107 0

X108 NM108 BLB4 WL12 Vdd Gnd BC
Vtest108 BL4 NM108 0

X109 NM109 BLB4 WL13 Vdd Gnd BC
Vtest109 BL4 NM109 0

X110 NM110 BLB4 WL14 Vdd Gnd BC
Vtest110 BL4 NM110 0

X111 NM111 BLB4 WL15 Vdd Gnd BC
Vtest111 BL4 NM111 0

X112 NM112 BLB4 WL16 Vdd Gnd BC
Vtest112 BL4 NM112 0

X113 NM113 BLB4 WL17 Vdd Gnd BC
Vtest113 BL4 NM113 0

X114 NM114 BLB4 WL18 Vdd Gnd BC
Vtest114 BL4 NM114 0

X115 NM115 BLB4 WL19 Vdd Gnd BC
Vtest115 BL4 NM115 0

X116 NM116 BLB4 WL20 Vdd Gnd BC
Vtest116 BL4 NM116 0

X117 NM117 BLB4 WL21 Vdd Gnd BC
Vtest117 BL4 NM117 0

X118 NM118 BLB4 WL22 Vdd Gnd BC
Vtest118 BL4 NM118 0

X119 NM119 BLB4 WL23 Vdd Gnd BC
Vtest119 BL4 NM119 0

X120 NM120 BLB4 WL24 Vdd Gnd BC
Vtest120 BL4 NM120 0

X121 NM121 BLB4 WL25 Vdd Gnd BC
Vtest121 BL4 NM121 0

X122 NM122 BLB4 WL26 Vdd Gnd BC
Vtest122 BL4 NM122 0

X123 NM123 BLB4 WL27 Vdd Gnd BC
Vtest123 BL4 NM123 0

X124 NM124 BLB4 WL28 Vdd Gnd BC
Vtest124 BL4 NM124 0

X125 NM125 BLB4 WL29 Vdd Gnd BC
Vtest125 BL4 NM125 0

X126 NM126 BLB4 WL30 Vdd Gnd BC
Vtest126 BL4 NM126 0

X127 NM127 BLB4 WL31 Vdd Gnd BC
Vtest127 BL4 NM127 0

X128 NM128 BLB4 WL32 Vdd Gnd BC
Vtest128 BL4 NM128 0

X129 NM129 BLB5 WL1 Vdd Gnd BC
Vtest129 BL5 NM129 0

X130 NM130 BLB5 WL2 Vdd Gnd BC
Vtest130 BL5 NM130 0

X131 NM131 BLB5 WL3 Vdd Gnd BC
Vtest131 BL5 NM131 0

X132 NM132 BLB5 WL4 Vdd Gnd BC
Vtest132 BL5 NM132 0

X133 NM133 BLB5 WL5 Vdd Gnd BC
Vtest133 BL5 NM133 0

X134 NM134 BLB5 WL6 Vdd Gnd BC
Vtest134 BL5 NM134 0

X135 NM135 BLB5 WL7 Vdd Gnd BC
Vtest135 BL5 NM135 0

X136 NM136 BLB5 WL8 Vdd Gnd BC
Vtest136 BL5 NM136 0

X137 NM137 BLB5 WL9 Vdd Gnd BC
Vtest137 BL5 NM137 0

X138 NM138 BLB5 WL10 Vdd Gnd BC
Vtest138 BL5 NM138 0

X139 NM139 BLB5 WL11 Vdd Gnd BC
Vtest139 BL5 NM139 0

X140 NM140 BLB5 WL12 Vdd Gnd BC
Vtest140 BL5 NM140 0

X141 NM141 BLB5 WL13 Vdd Gnd BC
Vtest141 BL5 NM141 0

X142 NM142 BLB5 WL14 Vdd Gnd BC
Vtest142 BL5 NM142 0

X143 NM143 BLB5 WL15 Vdd Gnd BC
Vtest143 BL5 NM143 0

X144 NM144 BLB5 WL16 Vdd Gnd BC
Vtest144 BL5 NM144 0

X145 NM145 BLB5 WL17 Vdd Gnd BC
Vtest145 BL5 NM145 0

X146 NM146 BLB5 WL18 Vdd Gnd BC
Vtest146 BL5 NM146 0

X147 NM147 BLB5 WL19 Vdd Gnd BC
Vtest147 BL5 NM147 0

X148 NM148 BLB5 WL20 Vdd Gnd BC
Vtest148 BL5 NM148 0

X149 NM149 BLB5 WL21 Vdd Gnd BC
Vtest149 BL5 NM149 0

X150 NM150 BLB5 WL22 Vdd Gnd BC
Vtest150 BL5 NM150 0

X151 NM151 BLB5 WL23 Vdd Gnd BC
Vtest151 BL5 NM151 0

X152 NM152 BLB5 WL24 Vdd Gnd BC
Vtest152 BL5 NM152 0

X153 NM153 BLB5 WL25 Vdd Gnd BC
Vtest153 BL5 NM153 0

X154 NM154 BLB5 WL26 Vdd Gnd BC
Vtest154 BL5 NM154 0

X155 NM155 BLB5 WL27 Vdd Gnd BC
Vtest155 BL5 NM155 0

X156 NM156 BLB5 WL28 Vdd Gnd BC
Vtest156 BL5 NM156 0

X157 NM157 BLB5 WL29 Vdd Gnd BC
Vtest157 BL5 NM157 0

X158 NM158 BLB5 WL30 Vdd Gnd BC
Vtest158 BL5 NM158 0

X159 NM159 BLB5 WL31 Vdd Gnd BC
Vtest159 BL5 NM159 0

X160 NM160 BLB5 WL32 Vdd Gnd BC
Vtest160 BL5 NM160 0

X161 NM161 BLB6 WL1 Vdd Gnd BC
Vtest161 BL6 NM161 0

X162 NM162 BLB6 WL2 Vdd Gnd BC
Vtest162 BL6 NM162 0

X163 NM163 BLB6 WL3 Vdd Gnd BC
Vtest163 BL6 NM163 0

X164 NM164 BLB6 WL4 Vdd Gnd BC
Vtest164 BL6 NM164 0

X165 NM165 BLB6 WL5 Vdd Gnd BC
Vtest165 BL6 NM165 0

X166 NM166 BLB6 WL6 Vdd Gnd BC
Vtest166 BL6 NM166 0

X167 NM167 BLB6 WL7 Vdd Gnd BC
Vtest167 BL6 NM167 0

X168 NM168 BLB6 WL8 Vdd Gnd BC
Vtest168 BL6 NM168 0

X169 NM169 BLB6 WL9 Vdd Gnd BC
Vtest169 BL6 NM169 0

X170 NM170 BLB6 WL10 Vdd Gnd BC
Vtest170 BL6 NM170 0

X171 NM171 BLB6 WL11 Vdd Gnd BC
Vtest171 BL6 NM171 0

X172 NM172 BLB6 WL12 Vdd Gnd BC
Vtest172 BL6 NM172 0

X173 NM173 BLB6 WL13 Vdd Gnd BC
Vtest173 BL6 NM173 0

X174 NM174 BLB6 WL14 Vdd Gnd BC
Vtest174 BL6 NM174 0

X175 NM175 BLB6 WL15 Vdd Gnd BC
Vtest175 BL6 NM175 0

X176 NM176 BLB6 WL16 Vdd Gnd BC
Vtest176 BL6 NM176 0

X177 NM177 BLB6 WL17 Vdd Gnd BC
Vtest177 BL6 NM177 0

X178 NM178 BLB6 WL18 Vdd Gnd BC
Vtest178 BL6 NM178 0

X179 NM179 BLB6 WL19 Vdd Gnd BC
Vtest179 BL6 NM179 0

X180 NM180 BLB6 WL20 Vdd Gnd BC
Vtest180 BL6 NM180 0

X181 NM181 BLB6 WL21 Vdd Gnd BC
Vtest181 BL6 NM181 0

X182 NM182 BLB6 WL22 Vdd Gnd BC
Vtest182 BL6 NM182 0

X183 NM183 BLB6 WL23 Vdd Gnd BC
Vtest183 BL6 NM183 0

X184 NM184 BLB6 WL24 Vdd Gnd BC
Vtest184 BL6 NM184 0

X185 NM185 BLB6 WL25 Vdd Gnd BC
Vtest185 BL6 NM185 0

X186 NM186 BLB6 WL26 Vdd Gnd BC
Vtest186 BL6 NM186 0

X187 NM187 BLB6 WL27 Vdd Gnd BC
Vtest187 BL6 NM187 0

X188 NM188 BLB6 WL28 Vdd Gnd BC
Vtest188 BL6 NM188 0

X189 NM189 BLB6 WL29 Vdd Gnd BC
Vtest189 BL6 NM189 0

X190 NM190 BLB6 WL30 Vdd Gnd BC
Vtest190 BL6 NM190 0

X191 NM191 BLB6 WL31 Vdd Gnd BC
Vtest191 BL6 NM191 0

X192 NM192 BLB6 WL32 Vdd Gnd BC
Vtest192 BL6 NM192 0

X193 NM193 BLB7 WL1 Vdd Gnd BC
Vtest193 BL7 NM193 0

X194 NM194 BLB7 WL2 Vdd Gnd BC
Vtest194 BL7 NM194 0

X195 NM195 BLB7 WL3 Vdd Gnd BC
Vtest195 BL7 NM195 0

X196 NM196 BLB7 WL4 Vdd Gnd BC
Vtest196 BL7 NM196 0

X197 NM197 BLB7 WL5 Vdd Gnd BC
Vtest197 BL7 NM197 0

X198 NM198 BLB7 WL6 Vdd Gnd BC
Vtest198 BL7 NM198 0

X199 NM199 BLB7 WL7 Vdd Gnd BC
Vtest199 BL7 NM199 0

X200 NM200 BLB7 WL8 Vdd Gnd BC
Vtest200 BL7 NM200 0

X201 NM201 BLB7 WL9 Vdd Gnd BC
Vtest201 BL7 NM201 0

X202 NM202 BLB7 WL10 Vdd Gnd BC
Vtest202 BL7 NM202 0

X203 NM203 BLB7 WL11 Vdd Gnd BC
Vtest203 BL7 NM203 0

X204 NM204 BLB7 WL12 Vdd Gnd BC
Vtest204 BL7 NM204 0

X205 NM205 BLB7 WL13 Vdd Gnd BC
Vtest205 BL7 NM205 0

X206 NM206 BLB7 WL14 Vdd Gnd BC
Vtest206 BL7 NM206 0

X207 NM207 BLB7 WL15 Vdd Gnd BC
Vtest207 BL7 NM207 0

X208 NM208 BLB7 WL16 Vdd Gnd BC
Vtest208 BL7 NM208 0

X209 NM209 BLB7 WL17 Vdd Gnd BC
Vtest209 BL7 NM209 0

X210 NM210 BLB7 WL18 Vdd Gnd BC
Vtest210 BL7 NM210 0

X211 NM211 BLB7 WL19 Vdd Gnd BC
Vtest211 BL7 NM211 0

X212 NM212 BLB7 WL20 Vdd Gnd BC
Vtest212 BL7 NM212 0

X213 NM213 BLB7 WL21 Vdd Gnd BC
Vtest213 BL7 NM213 0

X214 NM214 BLB7 WL22 Vdd Gnd BC
Vtest214 BL7 NM214 0

X215 NM215 BLB7 WL23 Vdd Gnd BC
Vtest215 BL7 NM215 0

X216 NM216 BLB7 WL24 Vdd Gnd BC
Vtest216 BL7 NM216 0

X217 NM217 BLB7 WL25 Vdd Gnd BC
Vtest217 BL7 NM217 0

X218 NM218 BLB7 WL26 Vdd Gnd BC
Vtest218 BL7 NM218 0

X219 NM219 BLB7 WL27 Vdd Gnd BC
Vtest219 BL7 NM219 0

X220 NM220 BLB7 WL28 Vdd Gnd BC
Vtest220 BL7 NM220 0

X221 NM221 BLB7 WL29 Vdd Gnd BC
Vtest221 BL7 NM221 0

X222 NM222 BLB7 WL30 Vdd Gnd BC
Vtest222 BL7 NM222 0

X223 NM223 BLB7 WL31 Vdd Gnd BC
Vtest223 BL7 NM223 0

X224 NM224 BLB7 WL32 Vdd Gnd BC
Vtest224 BL7 NM224 0

X225 NM225 BLB8 WL1 Vdd Gnd BC
Vtest225 BL8 NM225 0

X226 NM226 BLB8 WL2 Vdd Gnd BC
Vtest226 BL8 NM226 0

X227 NM227 BLB8 WL3 Vdd Gnd BC
Vtest227 BL8 NM227 0

X228 NM228 BLB8 WL4 Vdd Gnd BC
Vtest228 BL8 NM228 0

X229 NM229 BLB8 WL5 Vdd Gnd BC
Vtest229 BL8 NM229 0

X230 NM230 BLB8 WL6 Vdd Gnd BC
Vtest230 BL8 NM230 0

X231 NM231 BLB8 WL7 Vdd Gnd BC
Vtest231 BL8 NM231 0

X232 NM232 BLB8 WL8 Vdd Gnd BC
Vtest232 BL8 NM232 0

X233 NM233 BLB8 WL9 Vdd Gnd BC
Vtest233 BL8 NM233 0

X234 NM234 BLB8 WL10 Vdd Gnd BC
Vtest234 BL8 NM234 0

X235 NM235 BLB8 WL11 Vdd Gnd BC
Vtest235 BL8 NM235 0

X236 NM236 BLB8 WL12 Vdd Gnd BC
Vtest236 BL8 NM236 0

X237 NM237 BLB8 WL13 Vdd Gnd BC
Vtest237 BL8 NM237 0

X238 NM238 BLB8 WL14 Vdd Gnd BC
Vtest238 BL8 NM238 0

X239 NM239 BLB8 WL15 Vdd Gnd BC
Vtest239 BL8 NM239 0

X240 NM240 BLB8 WL16 Vdd Gnd BC
Vtest240 BL8 NM240 0

X241 NM241 BLB8 WL17 Vdd Gnd BC
Vtest241 BL8 NM241 0

X242 NM242 BLB8 WL18 Vdd Gnd BC
Vtest242 BL8 NM242 0

X243 NM243 BLB8 WL19 Vdd Gnd BC
Vtest243 BL8 NM243 0

X244 NM244 BLB8 WL20 Vdd Gnd BC
Vtest244 BL8 NM244 0

X245 NM245 BLB8 WL21 Vdd Gnd BC
Vtest245 BL8 NM245 0

X246 NM246 BLB8 WL22 Vdd Gnd BC
Vtest246 BL8 NM246 0

X247 NM247 BLB8 WL23 Vdd Gnd BC
Vtest247 BL8 NM247 0

X248 NM248 BLB8 WL24 Vdd Gnd BC
Vtest248 BL8 NM248 0

X249 NM249 BLB8 WL25 Vdd Gnd BC
Vtest249 BL8 NM249 0

X250 NM250 BLB8 WL26 Vdd Gnd BC
Vtest250 BL8 NM250 0

X251 NM251 BLB8 WL27 Vdd Gnd BC
Vtest251 BL8 NM251 0

X252 NM252 BLB8 WL28 Vdd Gnd BC
Vtest252 BL8 NM252 0

X253 NM253 BLB8 WL29 Vdd Gnd BC
Vtest253 BL8 NM253 0

X254 NM254 BLB8 WL30 Vdd Gnd BC
Vtest254 BL8 NM254 0

X255 NM255 BLB8 WL31 Vdd Gnd BC
Vtest255 BL8 NM255 0

X256 NM256 BLB8 WL32 Vdd Gnd BC
Vtest256 BL8 NM256 0

* Write Driver

X257 WD1 BL1 EN1 ENB1 Vdd Gnd TI
X258 WD2 BL2 EN2 ENB2 Vdd Gnd TI
X259 WD3 BL3 EN3 ENB3 Vdd Gnd TI
X260 WD4 BL4 EN4 ENB4 Vdd Gnd TI
X261 WD5 BL5 EN5 ENB5 Vdd Gnd TI
X262 WD6 BL6 EN6 ENB6 Vdd Gnd TI
X263 WD7 BL7 EN7 ENB7 Vdd Gnd TI
X264 WD8 BL8 EN8 ENB8 Vdd Gnd TI

X289 WDB1 BLB1 EN1 ENB1 Vdd Gnd TI
X290 WDB2 BLB2 EN2 ENB2 Vdd Gnd TI
X291 WDB3 BLB3 EN3 ENB3 Vdd Gnd TI
X292 WDB4 BLB4 EN4 ENB4 Vdd Gnd TI
X293 WDB5 BLB5 EN5 ENB5 Vdd Gnd TI
X294 WDB6 BLB6 EN6 ENB6 Vdd Gnd TI
X295 WDB7 BLB7 EN7 ENB7 Vdd Gnd TI
X296 WDB8 BLB8 EN8 ENB8 Vdd Gnd TI

* Pre charge

X321 BL1 BLB1 PRE1 Vdd PC
X322 BL2 BLB2 PRE2 Vdd PC
X323 BL3 BLB3 PRE3 Vdd PC
X324 BL4 BLB4 PRE4 Vdd PC
X325 BL5 BLB5 PRE5 Vdd PC
X326 BL6 BLB6 PRE6 Vdd PC
X327 BL7 BLB7 PRE7 Vdd PC
X328 BL8 BLB8 PRE8 Vdd PC

* Bitlines Capacitance

Cbl1 BL1 Gnd 'cap'
Cbl2 BL2 Gnd 'cap'
Cbl3 BL3 Gnd 'cap'
Cbl4 BL4 Gnd 'cap'
Cbl5 BL5 Gnd 'cap'
Cbl6 BL6 Gnd 'cap'
Cbl7 BL7 Gnd 'cap'
Cbl8 BL8 Gnd 'cap'
Cblb1 BLB1 Gnd 'cap'
Cblb2 BLB2 Gnd 'cap'
Cblb3 BLB3 Gnd 'cap'
Cblb4 BLB4 Gnd 'cap'
Cblb5 BLB5 Gnd 'cap'
Cblb6 BLB6 Gnd 'cap'
Cblb7 BLB7 Gnd 'cap'
Cblb8 BLB8 Gnd 'cap'

.TRAN 1p 10n

.option rawfmt="psfbin"

.IC V(X112.Q)=0 V(X112.QB)=1 V(BL4)=1 V(BLB4)=1
