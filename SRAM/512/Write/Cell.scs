* SRAM memory core

simulator lang=spice

.include '45nm_LP.pm'
.include '6TBitCell.spi'
.include 'TRISTATE.spi'
.include 'PreCharge.spi'
.include 'PassTransistor.spi'

.param VPre = 1
.param TpEn = 0.5n
.param TpWl = 1n
.param cap = 15f

Vwl1 WL1 Gnd PWL 0 0
Vwl2 WL2 Gnd PWL 0 0
Vwl3 WL3 Gnd PWL 0 0
Vwl4 WL4 Gnd PWL 0 0
Vwl5 WL5 Gnd PWL 0 0
Vwl6 WL6 Gnd PWL 0 0
Vwl7 WL7 Gnd PWL 0 0
Vwl8 WL8 Gnd PWL 0 0
Vwl9 WL9 Gnd PWL 0 0
Vwl10 WL10 Gnd PWL 0 0
Vwl11 WL11 Gnd PWL 0 0
Vwl12 WL12 Gnd PWL 0 0
Vwl13 WL13 Gnd PWL 0 0
Vwl14 WL14 Gnd PWL 0 0
Vwl15 WL15 Gnd PWL 0 0
Vwl16 WL16 Gnd PWL 0 0
Vwl17 WL17 Gnd PWL 0 0
Vwl18 WL18 Gnd PWL 0 0
Vwl19 WL19 Gnd PWL 0 0
Vwl20 WL20 Gnd PWL 0 0
Vwl21 WL21 Gnd PWL 0 0
Vwl22 WL22 Gnd PWL 0 0
Vwl23 WL23 Gnd PWL 0 0
Vwl24 WL24 Gnd PWL 0 0
Vwl25 WL25 Gnd PWL 0 0
Vwl26 WL26 Gnd PWL 0 0
Vwl27 WL27 Gnd PWL 0 0
Vwl28 WL28 Gnd PWL 0 0
Vwl29 WL29 Gnd PWL 0 0
Vwl30 WL30 Gnd PWL 0 0
Vwl31 WL31 Gnd PWL 0 0
Vwl32 WL32 Gnd PWL 0 0 '(TpWl)' 0 '(TpWl+1p)' 1 (1.5n+2p) 1 (1.5n+3p) 0
Vwl33 WL33 Gnd PWL 0 0
Vwl34 WL34 Gnd PWL 0 0
Vwl35 WL35 Gnd PWL 0 0
Vwl36 WL36 Gnd PWL 0 0
Vwl37 WL37 Gnd PWL 0 0
Vwl38 WL38 Gnd PWL 0 0
Vwl39 WL39 Gnd PWL 0 0
Vwl40 WL40 Gnd PWL 0 0
Vwl41 WL41 Gnd PWL 0 0
Vwl42 WL42 Gnd PWL 0 0
Vwl43 WL43 Gnd PWL 0 0
Vwl44 WL44 Gnd PWL 0 0
Vwl45 WL45 Gnd PWL 0 0
Vwl46 WL46 Gnd PWL 0 0
Vwl47 WL47 Gnd PWL 0 0
Vwl48 WL48 Gnd PWL 0 0
Vwl49 WL49 Gnd PWL 0 0
Vwl50 WL50 Gnd PWL 0 0
Vwl51 WL51 Gnd PWL 0 0
Vwl52 WL52 Gnd PWL 0 0
Vwl53 WL53 Gnd PWL 0 0
Vwl54 WL54 Gnd PWL 0 0
Vwl55 WL55 Gnd PWL 0 0
Vwl56 WL56 Gnd PWL 0 0
Vwl57 WL57 Gnd PWL 0 0
Vwl58 WL58 Gnd PWL 0 0
Vwl59 WL59 Gnd PWL 0 0
Vwl60 WL60 Gnd PWL 0 0
Vwl61 WL61 Gnd PWL 0 0
Vwl62 WL62 Gnd PWL 0 0
Vwl63 WL63 Gnd PWL 0 0
Vwl64 WL64 Gnd PWL 0 0

Vwd1 WD1 Gnd 0
Vwd2 WD2 Gnd 0
Vwd3 WD3 Gnd 0
Vwd4 WD4 Gnd 0
Vwd5 WD5 Gnd 0
Vwd6 WD6 Gnd 0
Vwd7 WD7 Gnd 0
Vwd8 WD8 Gnd 0

Vwdb1 WDB1 Gnd 1
Vwdb2 WDB2 Gnd 1
Vwdb3 WDB3 Gnd 1
Vwdb4 WDB4 Gnd 1
Vwdb5 WDB5 Gnd 1
Vwdb6 WDB6 Gnd 1
Vwdb7 WDB7 Gnd 1
Vwdb8 WDB8 Gnd 1

Ven1 EN1 Gnd 0
Ven2 EN2 Gnd 0
Ven3 EN3 Gnd 0
Ven4 EN4 Gnd PWL 0 0 '(TpEn-1p)' 0 'TpEn' 1 1.5n 1 (1.5n+1p) 0
Ven5 EN5 Gnd 0
Ven6 EN6 Gnd 0
Ven7 EN7 Gnd 0
Ven8 EN8 Gnd 0

Venb1 ENB1 Gnd 1
Venb2 ENB2 Gnd 1
Venb3 ENB3 Gnd 1
Venb4 ENB4 Gnd PWL 0 1 '(TpEn-1p)' 1 'TpEn' 0 1.5n 0 (1.5n+1p) 1
Venb5 ENB5 Gnd 1
Venb6 ENB6 Gnd 1
Venb7 ENB7 Gnd 1
Venb8 ENB8 Gnd 1

Vpre1 PRE1 Gnd 1
Vpre2 PRE2 Gnd 1
Vpre3 PRE3 Gnd 1
Vpre4 PRE4 Gnd 1
Vpre5 PRE5 Gnd 1
Vpre6 PRE6 Gnd 1
Vpre7 PRE7 Gnd 1
Vpre8 PRE8 Gnd 1

Vvdd Vvdd Gnd 1
Vdd Vdd Gnd 1
Vdd1 Vdd1 Gnd 1
Vgnd Gnd 0 0
* Bitcell

X1 NM1 BLB1 WL1 Vdd Gnd BC
Vtest1 BL1 NM1 0

X2 NM2 BLB1 WL2 Vdd Gnd BC
Vtest2 BL1 NM2 0

X3 NM3 BLB1 WL3 Vdd Gnd BC
Vtest3 BL1 NM3 0

X4 NM4 BLB1 WL4 Vdd Gnd BC
Vtest4 BL1 NM4 0

X5 NM5 BLB1 WL5 Vdd Gnd BC
Vtest5 BL1 NM5 0

X6 NM6 BLB1 WL6 Vdd Gnd BC
Vtest6 BL1 NM6 0

X7 NM7 BLB1 WL7 Vdd Gnd BC
Vtest7 BL1 NM7 0

X8 NM8 BLB1 WL8 Vdd Gnd BC
Vtest8 BL1 NM8 0

X9 NM9 BLB1 WL9 Vdd Gnd BC
Vtest9 BL1 NM9 0

X10 NM10 BLB1 WL10 Vdd Gnd BC
Vtest10 BL1 NM10 0

X11 NM11 BLB1 WL11 Vdd Gnd BC
Vtest11 BL1 NM11 0

X12 NM12 BLB1 WL12 Vdd Gnd BC
Vtest12 BL1 NM12 0

X13 NM13 BLB1 WL13 Vdd Gnd BC
Vtest13 BL1 NM13 0

X14 NM14 BLB1 WL14 Vdd Gnd BC
Vtest14 BL1 NM14 0

X15 NM15 BLB1 WL15 Vdd Gnd BC
Vtest15 BL1 NM15 0

X16 NM16 BLB1 WL16 Vdd Gnd BC
Vtest16 BL1 NM16 0

X17 NM17 BLB1 WL17 Vdd Gnd BC
Vtest17 BL1 NM17 0

X18 NM18 BLB1 WL18 Vdd Gnd BC
Vtest18 BL1 NM18 0

X19 NM19 BLB1 WL19 Vdd Gnd BC
Vtest19 BL1 NM19 0

X20 NM20 BLB1 WL20 Vdd Gnd BC
Vtest20 BL1 NM20 0

X21 NM21 BLB1 WL21 Vdd Gnd BC
Vtest21 BL1 NM21 0

X22 NM22 BLB1 WL22 Vdd Gnd BC
Vtest22 BL1 NM22 0

X23 NM23 BLB1 WL23 Vdd Gnd BC
Vtest23 BL1 NM23 0

X24 NM24 BLB1 WL24 Vdd Gnd BC
Vtest24 BL1 NM24 0

X25 NM25 BLB1 WL25 Vdd Gnd BC
Vtest25 BL1 NM25 0

X26 NM26 BLB1 WL26 Vdd Gnd BC
Vtest26 BL1 NM26 0

X27 NM27 BLB1 WL27 Vdd Gnd BC
Vtest27 BL1 NM27 0

X28 NM28 BLB1 WL28 Vdd Gnd BC
Vtest28 BL1 NM28 0

X29 NM29 BLB1 WL29 Vdd Gnd BC
Vtest29 BL1 NM29 0

X30 NM30 BLB1 WL30 Vdd Gnd BC
Vtest30 BL1 NM30 0

X31 NM31 BLB1 WL31 Vdd Gnd BC
Vtest31 BL1 NM31 0

X32 NM32 BLB1 WL32 Vdd Gnd BC
Vtest32 BL1 NM32 0

X33 NM33 BLB1 WL33 Vdd Gnd BC
Vtest33 BL1 NM33 0

X34 NM34 BLB1 WL34 Vdd Gnd BC
Vtest34 BL1 NM34 0

X35 NM35 BLB1 WL35 Vdd Gnd BC
Vtest35 BL1 NM35 0

X36 NM36 BLB1 WL36 Vdd Gnd BC
Vtest36 BL1 NM36 0

X37 NM37 BLB1 WL37 Vdd Gnd BC
Vtest37 BL1 NM37 0

X38 NM38 BLB1 WL38 Vdd Gnd BC
Vtest38 BL1 NM38 0

X39 NM39 BLB1 WL39 Vdd Gnd BC
Vtest39 BL1 NM39 0

X40 NM40 BLB1 WL40 Vdd Gnd BC
Vtest40 BL1 NM40 0

X41 NM41 BLB1 WL41 Vdd Gnd BC
Vtest41 BL1 NM41 0

X42 NM42 BLB1 WL42 Vdd Gnd BC
Vtest42 BL1 NM42 0

X43 NM43 BLB1 WL43 Vdd Gnd BC
Vtest43 BL1 NM43 0

X44 NM44 BLB1 WL44 Vdd Gnd BC
Vtest44 BL1 NM44 0

X45 NM45 BLB1 WL45 Vdd Gnd BC
Vtest45 BL1 NM45 0

X46 NM46 BLB1 WL46 Vdd Gnd BC
Vtest46 BL1 NM46 0

X47 NM47 BLB1 WL47 Vdd Gnd BC
Vtest47 BL1 NM47 0

X48 NM48 BLB1 WL48 Vdd Gnd BC
Vtest48 BL1 NM48 0

X49 NM49 BLB1 WL49 Vdd Gnd BC
Vtest49 BL1 NM49 0

X50 NM50 BLB1 WL50 Vdd Gnd BC
Vtest50 BL1 NM50 0

X51 NM51 BLB1 WL51 Vdd Gnd BC
Vtest51 BL1 NM51 0

X52 NM52 BLB1 WL52 Vdd Gnd BC
Vtest52 BL1 NM52 0

X53 NM53 BLB1 WL53 Vdd Gnd BC
Vtest53 BL1 NM53 0

X54 NM54 BLB1 WL54 Vdd Gnd BC
Vtest54 BL1 NM54 0

X55 NM55 BLB1 WL55 Vdd Gnd BC
Vtest55 BL1 NM55 0

X56 NM56 BLB1 WL56 Vdd Gnd BC
Vtest56 BL1 NM56 0

X57 NM57 BLB1 WL57 Vdd Gnd BC
Vtest57 BL1 NM57 0

X58 NM58 BLB1 WL58 Vdd Gnd BC
Vtest58 BL1 NM58 0

X59 NM59 BLB1 WL59 Vdd Gnd BC
Vtest59 BL1 NM59 0

X60 NM60 BLB1 WL60 Vdd Gnd BC
Vtest60 BL1 NM60 0

X61 NM61 BLB1 WL61 Vdd Gnd BC
Vtest61 BL1 NM61 0

X62 NM62 BLB1 WL62 Vdd Gnd BC
Vtest62 BL1 NM62 0

X63 NM63 BLB1 WL63 Vdd Gnd BC
Vtest63 BL1 NM63 0

X64 NM64 BLB1 WL64 Vdd Gnd BC
Vtest64 BL1 NM64 0

X65 NM65 BLB2 WL1 Vdd Gnd BC
Vtest65 BL2 NM65 0

X66 NM66 BLB2 WL2 Vdd Gnd BC
Vtest66 BL2 NM66 0

X67 NM67 BLB2 WL3 Vdd Gnd BC
Vtest67 BL2 NM67 0

X68 NM68 BLB2 WL4 Vdd Gnd BC
Vtest68 BL2 NM68 0

X69 NM69 BLB2 WL5 Vdd Gnd BC
Vtest69 BL2 NM69 0

X70 NM70 BLB2 WL6 Vdd Gnd BC
Vtest70 BL2 NM70 0

X71 NM71 BLB2 WL7 Vdd Gnd BC
Vtest71 BL2 NM71 0

X72 NM72 BLB2 WL8 Vdd Gnd BC
Vtest72 BL2 NM72 0

X73 NM73 BLB2 WL9 Vdd Gnd BC
Vtest73 BL2 NM73 0

X74 NM74 BLB2 WL10 Vdd Gnd BC
Vtest74 BL2 NM74 0

X75 NM75 BLB2 WL11 Vdd Gnd BC
Vtest75 BL2 NM75 0

X76 NM76 BLB2 WL12 Vdd Gnd BC
Vtest76 BL2 NM76 0

X77 NM77 BLB2 WL13 Vdd Gnd BC
Vtest77 BL2 NM77 0

X78 NM78 BLB2 WL14 Vdd Gnd BC
Vtest78 BL2 NM78 0

X79 NM79 BLB2 WL15 Vdd Gnd BC
Vtest79 BL2 NM79 0

X80 NM80 BLB2 WL16 Vdd Gnd BC
Vtest80 BL2 NM80 0

X81 NM81 BLB2 WL17 Vdd Gnd BC
Vtest81 BL2 NM81 0

X82 NM82 BLB2 WL18 Vdd Gnd BC
Vtest82 BL2 NM82 0

X83 NM83 BLB2 WL19 Vdd Gnd BC
Vtest83 BL2 NM83 0

X84 NM84 BLB2 WL20 Vdd Gnd BC
Vtest84 BL2 NM84 0

X85 NM85 BLB2 WL21 Vdd Gnd BC
Vtest85 BL2 NM85 0

X86 NM86 BLB2 WL22 Vdd Gnd BC
Vtest86 BL2 NM86 0

X87 NM87 BLB2 WL23 Vdd Gnd BC
Vtest87 BL2 NM87 0

X88 NM88 BLB2 WL24 Vdd Gnd BC
Vtest88 BL2 NM88 0

X89 NM89 BLB2 WL25 Vdd Gnd BC
Vtest89 BL2 NM89 0

X90 NM90 BLB2 WL26 Vdd Gnd BC
Vtest90 BL2 NM90 0

X91 NM91 BLB2 WL27 Vdd Gnd BC
Vtest91 BL2 NM91 0

X92 NM92 BLB2 WL28 Vdd Gnd BC
Vtest92 BL2 NM92 0

X93 NM93 BLB2 WL29 Vdd Gnd BC
Vtest93 BL2 NM93 0

X94 NM94 BLB2 WL30 Vdd Gnd BC
Vtest94 BL2 NM94 0

X95 NM95 BLB2 WL31 Vdd Gnd BC
Vtest95 BL2 NM95 0

X96 NM96 BLB2 WL32 Vdd Gnd BC
Vtest96 BL2 NM96 0

X97 NM97 BLB2 WL33 Vdd Gnd BC
Vtest97 BL2 NM97 0

X98 NM98 BLB2 WL34 Vdd Gnd BC
Vtest98 BL2 NM98 0

X99 NM99 BLB2 WL35 Vdd Gnd BC
Vtest99 BL2 NM99 0

X100 NM100 BLB2 WL36 Vdd Gnd BC
Vtest100 BL2 NM100 0

X101 NM101 BLB2 WL37 Vdd Gnd BC
Vtest101 BL2 NM101 0

X102 NM102 BLB2 WL38 Vdd Gnd BC
Vtest102 BL2 NM102 0

X103 NM103 BLB2 WL39 Vdd Gnd BC
Vtest103 BL2 NM103 0

X104 NM104 BLB2 WL40 Vdd Gnd BC
Vtest104 BL2 NM104 0

X105 NM105 BLB2 WL41 Vdd Gnd BC
Vtest105 BL2 NM105 0

X106 NM106 BLB2 WL42 Vdd Gnd BC
Vtest106 BL2 NM106 0

X107 NM107 BLB2 WL43 Vdd Gnd BC
Vtest107 BL2 NM107 0

X108 NM108 BLB2 WL44 Vdd Gnd BC
Vtest108 BL2 NM108 0

X109 NM109 BLB2 WL45 Vdd Gnd BC
Vtest109 BL2 NM109 0

X110 NM110 BLB2 WL46 Vdd Gnd BC
Vtest110 BL2 NM110 0

X111 NM111 BLB2 WL47 Vdd Gnd BC
Vtest111 BL2 NM111 0

X112 NM112 BLB2 WL48 Vdd Gnd BC
Vtest112 BL2 NM112 0

X113 NM113 BLB2 WL49 Vdd Gnd BC
Vtest113 BL2 NM113 0

X114 NM114 BLB2 WL50 Vdd Gnd BC
Vtest114 BL2 NM114 0

X115 NM115 BLB2 WL51 Vdd Gnd BC
Vtest115 BL2 NM115 0

X116 NM116 BLB2 WL52 Vdd Gnd BC
Vtest116 BL2 NM116 0

X117 NM117 BLB2 WL53 Vdd Gnd BC
Vtest117 BL2 NM117 0

X118 NM118 BLB2 WL54 Vdd Gnd BC
Vtest118 BL2 NM118 0

X119 NM119 BLB2 WL55 Vdd Gnd BC
Vtest119 BL2 NM119 0

X120 NM120 BLB2 WL56 Vdd Gnd BC
Vtest120 BL2 NM120 0

X121 NM121 BLB2 WL57 Vdd Gnd BC
Vtest121 BL2 NM121 0

X122 NM122 BLB2 WL58 Vdd Gnd BC
Vtest122 BL2 NM122 0

X123 NM123 BLB2 WL59 Vdd Gnd BC
Vtest123 BL2 NM123 0

X124 NM124 BLB2 WL60 Vdd Gnd BC
Vtest124 BL2 NM124 0

X125 NM125 BLB2 WL61 Vdd Gnd BC
Vtest125 BL2 NM125 0

X126 NM126 BLB2 WL62 Vdd Gnd BC
Vtest126 BL2 NM126 0

X127 NM127 BLB2 WL63 Vdd Gnd BC
Vtest127 BL2 NM127 0

X128 NM128 BLB2 WL64 Vdd Gnd BC
Vtest128 BL2 NM128 0

X129 NM129 BLB3 WL1 Vdd Gnd BC
Vtest129 BL3 NM129 0

X130 NM130 BLB3 WL2 Vdd Gnd BC
Vtest130 BL3 NM130 0

X131 NM131 BLB3 WL3 Vdd Gnd BC
Vtest131 BL3 NM131 0

X132 NM132 BLB3 WL4 Vdd Gnd BC
Vtest132 BL3 NM132 0

X133 NM133 BLB3 WL5 Vdd Gnd BC
Vtest133 BL3 NM133 0

X134 NM134 BLB3 WL6 Vdd Gnd BC
Vtest134 BL3 NM134 0

X135 NM135 BLB3 WL7 Vdd Gnd BC
Vtest135 BL3 NM135 0

X136 NM136 BLB3 WL8 Vdd Gnd BC
Vtest136 BL3 NM136 0

X137 NM137 BLB3 WL9 Vdd Gnd BC
Vtest137 BL3 NM137 0

X138 NM138 BLB3 WL10 Vdd Gnd BC
Vtest138 BL3 NM138 0

X139 NM139 BLB3 WL11 Vdd Gnd BC
Vtest139 BL3 NM139 0

X140 NM140 BLB3 WL12 Vdd Gnd BC
Vtest140 BL3 NM140 0

X141 NM141 BLB3 WL13 Vdd Gnd BC
Vtest141 BL3 NM141 0

X142 NM142 BLB3 WL14 Vdd Gnd BC
Vtest142 BL3 NM142 0

X143 NM143 BLB3 WL15 Vdd Gnd BC
Vtest143 BL3 NM143 0

X144 NM144 BLB3 WL16 Vdd Gnd BC
Vtest144 BL3 NM144 0

X145 NM145 BLB3 WL17 Vdd Gnd BC
Vtest145 BL3 NM145 0

X146 NM146 BLB3 WL18 Vdd Gnd BC
Vtest146 BL3 NM146 0

X147 NM147 BLB3 WL19 Vdd Gnd BC
Vtest147 BL3 NM147 0

X148 NM148 BLB3 WL20 Vdd Gnd BC
Vtest148 BL3 NM148 0

X149 NM149 BLB3 WL21 Vdd Gnd BC
Vtest149 BL3 NM149 0

X150 NM150 BLB3 WL22 Vdd Gnd BC
Vtest150 BL3 NM150 0

X151 NM151 BLB3 WL23 Vdd Gnd BC
Vtest151 BL3 NM151 0

X152 NM152 BLB3 WL24 Vdd Gnd BC
Vtest152 BL3 NM152 0

X153 NM153 BLB3 WL25 Vdd Gnd BC
Vtest153 BL3 NM153 0

X154 NM154 BLB3 WL26 Vdd Gnd BC
Vtest154 BL3 NM154 0

X155 NM155 BLB3 WL27 Vdd Gnd BC
Vtest155 BL3 NM155 0

X156 NM156 BLB3 WL28 Vdd Gnd BC
Vtest156 BL3 NM156 0

X157 NM157 BLB3 WL29 Vdd Gnd BC
Vtest157 BL3 NM157 0

X158 NM158 BLB3 WL30 Vdd Gnd BC
Vtest158 BL3 NM158 0

X159 NM159 BLB3 WL31 Vdd Gnd BC
Vtest159 BL3 NM159 0

X160 NM160 BLB3 WL32 Vdd Gnd BC
Vtest160 BL3 NM160 0

X161 NM161 BLB3 WL33 Vdd Gnd BC
Vtest161 BL3 NM161 0

X162 NM162 BLB3 WL34 Vdd Gnd BC
Vtest162 BL3 NM162 0

X163 NM163 BLB3 WL35 Vdd Gnd BC
Vtest163 BL3 NM163 0

X164 NM164 BLB3 WL36 Vdd Gnd BC
Vtest164 BL3 NM164 0

X165 NM165 BLB3 WL37 Vdd Gnd BC
Vtest165 BL3 NM165 0

X166 NM166 BLB3 WL38 Vdd Gnd BC
Vtest166 BL3 NM166 0

X167 NM167 BLB3 WL39 Vdd Gnd BC
Vtest167 BL3 NM167 0

X168 NM168 BLB3 WL40 Vdd Gnd BC
Vtest168 BL3 NM168 0

X169 NM169 BLB3 WL41 Vdd Gnd BC
Vtest169 BL3 NM169 0

X170 NM170 BLB3 WL42 Vdd Gnd BC
Vtest170 BL3 NM170 0

X171 NM171 BLB3 WL43 Vdd Gnd BC
Vtest171 BL3 NM171 0

X172 NM172 BLB3 WL44 Vdd Gnd BC
Vtest172 BL3 NM172 0

X173 NM173 BLB3 WL45 Vdd Gnd BC
Vtest173 BL3 NM173 0

X174 NM174 BLB3 WL46 Vdd Gnd BC
Vtest174 BL3 NM174 0

X175 NM175 BLB3 WL47 Vdd Gnd BC
Vtest175 BL3 NM175 0

X176 NM176 BLB3 WL48 Vdd Gnd BC
Vtest176 BL3 NM176 0

X177 NM177 BLB3 WL49 Vdd Gnd BC
Vtest177 BL3 NM177 0

X178 NM178 BLB3 WL50 Vdd Gnd BC
Vtest178 BL3 NM178 0

X179 NM179 BLB3 WL51 Vdd Gnd BC
Vtest179 BL3 NM179 0

X180 NM180 BLB3 WL52 Vdd Gnd BC
Vtest180 BL3 NM180 0

X181 NM181 BLB3 WL53 Vdd Gnd BC
Vtest181 BL3 NM181 0

X182 NM182 BLB3 WL54 Vdd Gnd BC
Vtest182 BL3 NM182 0

X183 NM183 BLB3 WL55 Vdd Gnd BC
Vtest183 BL3 NM183 0

X184 NM184 BLB3 WL56 Vdd Gnd BC
Vtest184 BL3 NM184 0

X185 NM185 BLB3 WL57 Vdd Gnd BC
Vtest185 BL3 NM185 0

X186 NM186 BLB3 WL58 Vdd Gnd BC
Vtest186 BL3 NM186 0

X187 NM187 BLB3 WL59 Vdd Gnd BC
Vtest187 BL3 NM187 0

X188 NM188 BLB3 WL60 Vdd Gnd BC
Vtest188 BL3 NM188 0

X189 NM189 BLB3 WL61 Vdd Gnd BC
Vtest189 BL3 NM189 0

X190 NM190 BLB3 WL62 Vdd Gnd BC
Vtest190 BL3 NM190 0

X191 NM191 BLB3 WL63 Vdd Gnd BC
Vtest191 BL3 NM191 0

X192 NM192 BLB3 WL64 Vdd Gnd BC
Vtest192 BL3 NM192 0

X193 NM193 BLB4 WL1 Vdd Gnd BC
Vtest193 BL4 NM193 0

X194 NM194 BLB4 WL2 Vdd Gnd BC
Vtest194 BL4 NM194 0

X195 NM195 BLB4 WL3 Vdd Gnd BC
Vtest195 BL4 NM195 0

X196 NM196 BLB4 WL4 Vdd Gnd BC
Vtest196 BL4 NM196 0

X197 NM197 BLB4 WL5 Vdd Gnd BC
Vtest197 BL4 NM197 0

X198 NM198 BLB4 WL6 Vdd Gnd BC
Vtest198 BL4 NM198 0

X199 NM199 BLB4 WL7 Vdd Gnd BC
Vtest199 BL4 NM199 0

X200 NM200 BLB4 WL8 Vdd Gnd BC
Vtest200 BL4 NM200 0

X201 NM201 BLB4 WL9 Vdd Gnd BC
Vtest201 BL4 NM201 0

X202 NM202 BLB4 WL10 Vdd Gnd BC
Vtest202 BL4 NM202 0

X203 NM203 BLB4 WL11 Vdd Gnd BC
Vtest203 BL4 NM203 0

X204 NM204 BLB4 WL12 Vdd Gnd BC
Vtest204 BL4 NM204 0

X205 NM205 BLB4 WL13 Vdd Gnd BC
Vtest205 BL4 NM205 0

X206 NM206 BLB4 WL14 Vdd Gnd BC
Vtest206 BL4 NM206 0

X207 NM207 BLB4 WL15 Vdd Gnd BC
Vtest207 BL4 NM207 0

X208 NM208 BLB4 WL16 Vdd Gnd BC
Vtest208 BL4 NM208 0

X209 NM209 BLB4 WL17 Vdd Gnd BC
Vtest209 BL4 NM209 0

X210 NM210 BLB4 WL18 Vdd Gnd BC
Vtest210 BL4 NM210 0

X211 NM211 BLB4 WL19 Vdd Gnd BC
Vtest211 BL4 NM211 0

X212 NM212 BLB4 WL20 Vdd Gnd BC
Vtest212 BL4 NM212 0

X213 NM213 BLB4 WL21 Vdd Gnd BC
Vtest213 BL4 NM213 0

X214 NM214 BLB4 WL22 Vdd Gnd BC
Vtest214 BL4 NM214 0

X215 NM215 BLB4 WL23 Vdd Gnd BC
Vtest215 BL4 NM215 0

X216 NM216 BLB4 WL24 Vdd Gnd BC
Vtest216 BL4 NM216 0

X217 NM217 BLB4 WL25 Vdd Gnd BC
Vtest217 BL4 NM217 0

X218 NM218 BLB4 WL26 Vdd Gnd BC
Vtest218 BL4 NM218 0

X219 NM219 BLB4 WL27 Vdd Gnd BC
Vtest219 BL4 NM219 0

X220 NM220 BLB4 WL28 Vdd Gnd BC
Vtest220 BL4 NM220 0

X221 NM221 BLB4 WL29 Vdd Gnd BC
Vtest221 BL4 NM221 0

X222 NM222 BLB4 WL30 Vdd Gnd BC
Vtest222 BL4 NM222 0

X223 NM223 BLB4 WL31 Vdd Gnd BC
Vtest223 BL4 NM223 0

X224 NM224 BLB4 WL32 Vdd1 Gnd BC
Vtest224 BL4 NM224 0

X225 NM225 BLB4 WL33 Vdd Gnd BC
Vtest225 BL4 NM225 0

X226 NM226 BLB4 WL34 Vdd Gnd BC
Vtest226 BL4 NM226 0

X227 NM227 BLB4 WL35 Vdd Gnd BC
Vtest227 BL4 NM227 0

X228 NM228 BLB4 WL36 Vdd Gnd BC
Vtest228 BL4 NM228 0

X229 NM229 BLB4 WL37 Vdd Gnd BC
Vtest229 BL4 NM229 0

X230 NM230 BLB4 WL38 Vdd Gnd BC
Vtest230 BL4 NM230 0

X231 NM231 BLB4 WL39 Vdd Gnd BC
Vtest231 BL4 NM231 0

X232 NM232 BLB4 WL40 Vdd Gnd BC
Vtest232 BL4 NM232 0

X233 NM233 BLB4 WL41 Vdd Gnd BC
Vtest233 BL4 NM233 0

X234 NM234 BLB4 WL42 Vdd Gnd BC
Vtest234 BL4 NM234 0

X235 NM235 BLB4 WL43 Vdd Gnd BC
Vtest235 BL4 NM235 0

X236 NM236 BLB4 WL44 Vdd Gnd BC
Vtest236 BL4 NM236 0

X237 NM237 BLB4 WL45 Vdd Gnd BC
Vtest237 BL4 NM237 0

X238 NM238 BLB4 WL46 Vdd Gnd BC
Vtest238 BL4 NM238 0

X239 NM239 BLB4 WL47 Vdd Gnd BC
Vtest239 BL4 NM239 0

X240 NM240 BLB4 WL48 Vdd Gnd BC
Vtest240 BL4 NM240 0

X241 NM241 BLB4 WL49 Vdd Gnd BC
Vtest241 BL4 NM241 0

X242 NM242 BLB4 WL50 Vdd Gnd BC
Vtest242 BL4 NM242 0

X243 NM243 BLB4 WL51 Vdd Gnd BC
Vtest243 BL4 NM243 0

X244 NM244 BLB4 WL52 Vdd Gnd BC
Vtest244 BL4 NM244 0

X245 NM245 BLB4 WL53 Vdd Gnd BC
Vtest245 BL4 NM245 0

X246 NM246 BLB4 WL54 Vdd Gnd BC
Vtest246 BL4 NM246 0

X247 NM247 BLB4 WL55 Vdd Gnd BC
Vtest247 BL4 NM247 0

X248 NM248 BLB4 WL56 Vdd Gnd BC
Vtest248 BL4 NM248 0

X249 NM249 BLB4 WL57 Vdd Gnd BC
Vtest249 BL4 NM249 0

X250 NM250 BLB4 WL58 Vdd Gnd BC
Vtest250 BL4 NM250 0

X251 NM251 BLB4 WL59 Vdd Gnd BC
Vtest251 BL4 NM251 0

X252 NM252 BLB4 WL60 Vdd Gnd BC
Vtest252 BL4 NM252 0

X253 NM253 BLB4 WL61 Vdd Gnd BC
Vtest253 BL4 NM253 0

X254 NM254 BLB4 WL62 Vdd Gnd BC
Vtest254 BL4 NM254 0

X255 NM255 BLB4 WL63 Vdd Gnd BC
Vtest255 BL4 NM255 0

X256 NM256 BLB4 WL64 Vdd Gnd BC
Vtest256 BL4 NM256 0

X257 NM257 BLB5 WL1 Vdd Gnd BC
Vtest257 BL5 NM257 0

X258 NM258 BLB5 WL2 Vdd Gnd BC
Vtest258 BL5 NM258 0

X259 NM259 BLB5 WL3 Vdd Gnd BC
Vtest259 BL5 NM259 0

X260 NM260 BLB5 WL4 Vdd Gnd BC
Vtest260 BL5 NM260 0

X261 NM261 BLB5 WL5 Vdd Gnd BC
Vtest261 BL5 NM261 0

X262 NM262 BLB5 WL6 Vdd Gnd BC
Vtest262 BL5 NM262 0

X263 NM263 BLB5 WL7 Vdd Gnd BC
Vtest263 BL5 NM263 0

X264 NM264 BLB5 WL8 Vdd Gnd BC
Vtest264 BL5 NM264 0

X265 NM265 BLB5 WL9 Vdd Gnd BC
Vtest265 BL5 NM265 0

X266 NM266 BLB5 WL10 Vdd Gnd BC
Vtest266 BL5 NM266 0

X267 NM267 BLB5 WL11 Vdd Gnd BC
Vtest267 BL5 NM267 0

X268 NM268 BLB5 WL12 Vdd Gnd BC
Vtest268 BL5 NM268 0

X269 NM269 BLB5 WL13 Vdd Gnd BC
Vtest269 BL5 NM269 0

X270 NM270 BLB5 WL14 Vdd Gnd BC
Vtest270 BL5 NM270 0

X271 NM271 BLB5 WL15 Vdd Gnd BC
Vtest271 BL5 NM271 0

X272 NM272 BLB5 WL16 Vdd Gnd BC
Vtest272 BL5 NM272 0

X273 NM273 BLB5 WL17 Vdd Gnd BC
Vtest273 BL5 NM273 0

X274 NM274 BLB5 WL18 Vdd Gnd BC
Vtest274 BL5 NM274 0

X275 NM275 BLB5 WL19 Vdd Gnd BC
Vtest275 BL5 NM275 0

X276 NM276 BLB5 WL20 Vdd Gnd BC
Vtest276 BL5 NM276 0

X277 NM277 BLB5 WL21 Vdd Gnd BC
Vtest277 BL5 NM277 0

X278 NM278 BLB5 WL22 Vdd Gnd BC
Vtest278 BL5 NM278 0

X279 NM279 BLB5 WL23 Vdd Gnd BC
Vtest279 BL5 NM279 0

X280 NM280 BLB5 WL24 Vdd Gnd BC
Vtest280 BL5 NM280 0

X281 NM281 BLB5 WL25 Vdd Gnd BC
Vtest281 BL5 NM281 0

X282 NM282 BLB5 WL26 Vdd Gnd BC
Vtest282 BL5 NM282 0

X283 NM283 BLB5 WL27 Vdd Gnd BC
Vtest283 BL5 NM283 0

X284 NM284 BLB5 WL28 Vdd Gnd BC
Vtest284 BL5 NM284 0

X285 NM285 BLB5 WL29 Vdd Gnd BC
Vtest285 BL5 NM285 0

X286 NM286 BLB5 WL30 Vdd Gnd BC
Vtest286 BL5 NM286 0

X287 NM287 BLB5 WL31 Vdd Gnd BC
Vtest287 BL5 NM287 0

X288 NM288 BLB5 WL32 Vdd Gnd BC
Vtest288 BL5 NM288 0

X289 NM289 BLB5 WL33 Vdd Gnd BC
Vtest289 BL5 NM289 0

X290 NM290 BLB5 WL34 Vdd Gnd BC
Vtest290 BL5 NM290 0

X291 NM291 BLB5 WL35 Vdd Gnd BC
Vtest291 BL5 NM291 0

X292 NM292 BLB5 WL36 Vdd Gnd BC
Vtest292 BL5 NM292 0

X293 NM293 BLB5 WL37 Vdd Gnd BC
Vtest293 BL5 NM293 0

X294 NM294 BLB5 WL38 Vdd Gnd BC
Vtest294 BL5 NM294 0

X295 NM295 BLB5 WL39 Vdd Gnd BC
Vtest295 BL5 NM295 0

X296 NM296 BLB5 WL40 Vdd Gnd BC
Vtest296 BL5 NM296 0

X297 NM297 BLB5 WL41 Vdd Gnd BC
Vtest297 BL5 NM297 0

X298 NM298 BLB5 WL42 Vdd Gnd BC
Vtest298 BL5 NM298 0

X299 NM299 BLB5 WL43 Vdd Gnd BC
Vtest299 BL5 NM299 0

X300 NM300 BLB5 WL44 Vdd Gnd BC
Vtest300 BL5 NM300 0

X301 NM301 BLB5 WL45 Vdd Gnd BC
Vtest301 BL5 NM301 0

X302 NM302 BLB5 WL46 Vdd Gnd BC
Vtest302 BL5 NM302 0

X303 NM303 BLB5 WL47 Vdd Gnd BC
Vtest303 BL5 NM303 0

X304 NM304 BLB5 WL48 Vdd Gnd BC
Vtest304 BL5 NM304 0

X305 NM305 BLB5 WL49 Vdd Gnd BC
Vtest305 BL5 NM305 0

X306 NM306 BLB5 WL50 Vdd Gnd BC
Vtest306 BL5 NM306 0

X307 NM307 BLB5 WL51 Vdd Gnd BC
Vtest307 BL5 NM307 0

X308 NM308 BLB5 WL52 Vdd Gnd BC
Vtest308 BL5 NM308 0

X309 NM309 BLB5 WL53 Vdd Gnd BC
Vtest309 BL5 NM309 0

X310 NM310 BLB5 WL54 Vdd Gnd BC
Vtest310 BL5 NM310 0

X311 NM311 BLB5 WL55 Vdd Gnd BC
Vtest311 BL5 NM311 0

X312 NM312 BLB5 WL56 Vdd Gnd BC
Vtest312 BL5 NM312 0

X313 NM313 BLB5 WL57 Vdd Gnd BC
Vtest313 BL5 NM313 0

X314 NM314 BLB5 WL58 Vdd Gnd BC
Vtest314 BL5 NM314 0

X315 NM315 BLB5 WL59 Vdd Gnd BC
Vtest315 BL5 NM315 0

X316 NM316 BLB5 WL60 Vdd Gnd BC
Vtest316 BL5 NM316 0

X317 NM317 BLB5 WL61 Vdd Gnd BC
Vtest317 BL5 NM317 0

X318 NM318 BLB5 WL62 Vdd Gnd BC
Vtest318 BL5 NM318 0

X319 NM319 BLB5 WL63 Vdd Gnd BC
Vtest319 BL5 NM319 0

X320 NM320 BLB5 WL64 Vdd Gnd BC
Vtest320 BL5 NM320 0

X321 NM321 BLB6 WL1 Vdd Gnd BC
Vtest321 BL6 NM321 0

X322 NM322 BLB6 WL2 Vdd Gnd BC
Vtest322 BL6 NM322 0

X323 NM323 BLB6 WL3 Vdd Gnd BC
Vtest323 BL6 NM323 0

X324 NM324 BLB6 WL4 Vdd Gnd BC
Vtest324 BL6 NM324 0

X325 NM325 BLB6 WL5 Vdd Gnd BC
Vtest325 BL6 NM325 0

X326 NM326 BLB6 WL6 Vdd Gnd BC
Vtest326 BL6 NM326 0

X327 NM327 BLB6 WL7 Vdd Gnd BC
Vtest327 BL6 NM327 0

X328 NM328 BLB6 WL8 Vdd Gnd BC
Vtest328 BL6 NM328 0

X329 NM329 BLB6 WL9 Vdd Gnd BC
Vtest329 BL6 NM329 0

X330 NM330 BLB6 WL10 Vdd Gnd BC
Vtest330 BL6 NM330 0

X331 NM331 BLB6 WL11 Vdd Gnd BC
Vtest331 BL6 NM331 0

X332 NM332 BLB6 WL12 Vdd Gnd BC
Vtest332 BL6 NM332 0

X333 NM333 BLB6 WL13 Vdd Gnd BC
Vtest333 BL6 NM333 0

X334 NM334 BLB6 WL14 Vdd Gnd BC
Vtest334 BL6 NM334 0

X335 NM335 BLB6 WL15 Vdd Gnd BC
Vtest335 BL6 NM335 0

X336 NM336 BLB6 WL16 Vdd Gnd BC
Vtest336 BL6 NM336 0

X337 NM337 BLB6 WL17 Vdd Gnd BC
Vtest337 BL6 NM337 0

X338 NM338 BLB6 WL18 Vdd Gnd BC
Vtest338 BL6 NM338 0

X339 NM339 BLB6 WL19 Vdd Gnd BC
Vtest339 BL6 NM339 0

X340 NM340 BLB6 WL20 Vdd Gnd BC
Vtest340 BL6 NM340 0

X341 NM341 BLB6 WL21 Vdd Gnd BC
Vtest341 BL6 NM341 0

X342 NM342 BLB6 WL22 Vdd Gnd BC
Vtest342 BL6 NM342 0

X343 NM343 BLB6 WL23 Vdd Gnd BC
Vtest343 BL6 NM343 0

X344 NM344 BLB6 WL24 Vdd Gnd BC
Vtest344 BL6 NM344 0

X345 NM345 BLB6 WL25 Vdd Gnd BC
Vtest345 BL6 NM345 0

X346 NM346 BLB6 WL26 Vdd Gnd BC
Vtest346 BL6 NM346 0

X347 NM347 BLB6 WL27 Vdd Gnd BC
Vtest347 BL6 NM347 0

X348 NM348 BLB6 WL28 Vdd Gnd BC
Vtest348 BL6 NM348 0

X349 NM349 BLB6 WL29 Vdd Gnd BC
Vtest349 BL6 NM349 0

X350 NM350 BLB6 WL30 Vdd Gnd BC
Vtest350 BL6 NM350 0

X351 NM351 BLB6 WL31 Vdd Gnd BC
Vtest351 BL6 NM351 0

X352 NM352 BLB6 WL32 Vdd Gnd BC
Vtest352 BL6 NM352 0

X353 NM353 BLB6 WL33 Vdd Gnd BC
Vtest353 BL6 NM353 0

X354 NM354 BLB6 WL34 Vdd Gnd BC
Vtest354 BL6 NM354 0

X355 NM355 BLB6 WL35 Vdd Gnd BC
Vtest355 BL6 NM355 0

X356 NM356 BLB6 WL36 Vdd Gnd BC
Vtest356 BL6 NM356 0

X357 NM357 BLB6 WL37 Vdd Gnd BC
Vtest357 BL6 NM357 0

X358 NM358 BLB6 WL38 Vdd Gnd BC
Vtest358 BL6 NM358 0

X359 NM359 BLB6 WL39 Vdd Gnd BC
Vtest359 BL6 NM359 0

X360 NM360 BLB6 WL40 Vdd Gnd BC
Vtest360 BL6 NM360 0

X361 NM361 BLB6 WL41 Vdd Gnd BC
Vtest361 BL6 NM361 0

X362 NM362 BLB6 WL42 Vdd Gnd BC
Vtest362 BL6 NM362 0

X363 NM363 BLB6 WL43 Vdd Gnd BC
Vtest363 BL6 NM363 0

X364 NM364 BLB6 WL44 Vdd Gnd BC
Vtest364 BL6 NM364 0

X365 NM365 BLB6 WL45 Vdd Gnd BC
Vtest365 BL6 NM365 0

X366 NM366 BLB6 WL46 Vdd Gnd BC
Vtest366 BL6 NM366 0

X367 NM367 BLB6 WL47 Vdd Gnd BC
Vtest367 BL6 NM367 0

X368 NM368 BLB6 WL48 Vdd Gnd BC
Vtest368 BL6 NM368 0

X369 NM369 BLB6 WL49 Vdd Gnd BC
Vtest369 BL6 NM369 0

X370 NM370 BLB6 WL50 Vdd Gnd BC
Vtest370 BL6 NM370 0

X371 NM371 BLB6 WL51 Vdd Gnd BC
Vtest371 BL6 NM371 0

X372 NM372 BLB6 WL52 Vdd Gnd BC
Vtest372 BL6 NM372 0

X373 NM373 BLB6 WL53 Vdd Gnd BC
Vtest373 BL6 NM373 0

X374 NM374 BLB6 WL54 Vdd Gnd BC
Vtest374 BL6 NM374 0

X375 NM375 BLB6 WL55 Vdd Gnd BC
Vtest375 BL6 NM375 0

X376 NM376 BLB6 WL56 Vdd Gnd BC
Vtest376 BL6 NM376 0

X377 NM377 BLB6 WL57 Vdd Gnd BC
Vtest377 BL6 NM377 0

X378 NM378 BLB6 WL58 Vdd Gnd BC
Vtest378 BL6 NM378 0

X379 NM379 BLB6 WL59 Vdd Gnd BC
Vtest379 BL6 NM379 0

X380 NM380 BLB6 WL60 Vdd Gnd BC
Vtest380 BL6 NM380 0

X381 NM381 BLB6 WL61 Vdd Gnd BC
Vtest381 BL6 NM381 0

X382 NM382 BLB6 WL62 Vdd Gnd BC
Vtest382 BL6 NM382 0

X383 NM383 BLB6 WL63 Vdd Gnd BC
Vtest383 BL6 NM383 0

X384 NM384 BLB6 WL64 Vdd Gnd BC
Vtest384 BL6 NM384 0

X385 NM385 BLB7 WL1 Vdd Gnd BC
Vtest385 BL7 NM385 0

X386 NM386 BLB7 WL2 Vdd Gnd BC
Vtest386 BL7 NM386 0

X387 NM387 BLB7 WL3 Vdd Gnd BC
Vtest387 BL7 NM387 0

X388 NM388 BLB7 WL4 Vdd Gnd BC
Vtest388 BL7 NM388 0

X389 NM389 BLB7 WL5 Vdd Gnd BC
Vtest389 BL7 NM389 0

X390 NM390 BLB7 WL6 Vdd Gnd BC
Vtest390 BL7 NM390 0

X391 NM391 BLB7 WL7 Vdd Gnd BC
Vtest391 BL7 NM391 0

X392 NM392 BLB7 WL8 Vdd Gnd BC
Vtest392 BL7 NM392 0

X393 NM393 BLB7 WL9 Vdd Gnd BC
Vtest393 BL7 NM393 0

X394 NM394 BLB7 WL10 Vdd Gnd BC
Vtest394 BL7 NM394 0

X395 NM395 BLB7 WL11 Vdd Gnd BC
Vtest395 BL7 NM395 0

X396 NM396 BLB7 WL12 Vdd Gnd BC
Vtest396 BL7 NM396 0

X397 NM397 BLB7 WL13 Vdd Gnd BC
Vtest397 BL7 NM397 0

X398 NM398 BLB7 WL14 Vdd Gnd BC
Vtest398 BL7 NM398 0

X399 NM399 BLB7 WL15 Vdd Gnd BC
Vtest399 BL7 NM399 0

X400 NM400 BLB7 WL16 Vdd Gnd BC
Vtest400 BL7 NM400 0

X401 NM401 BLB7 WL17 Vdd Gnd BC
Vtest401 BL7 NM401 0

X402 NM402 BLB7 WL18 Vdd Gnd BC
Vtest402 BL7 NM402 0

X403 NM403 BLB7 WL19 Vdd Gnd BC
Vtest403 BL7 NM403 0

X404 NM404 BLB7 WL20 Vdd Gnd BC
Vtest404 BL7 NM404 0

X405 NM405 BLB7 WL21 Vdd Gnd BC
Vtest405 BL7 NM405 0

X406 NM406 BLB7 WL22 Vdd Gnd BC
Vtest406 BL7 NM406 0

X407 NM407 BLB7 WL23 Vdd Gnd BC
Vtest407 BL7 NM407 0

X408 NM408 BLB7 WL24 Vdd Gnd BC
Vtest408 BL7 NM408 0

X409 NM409 BLB7 WL25 Vdd Gnd BC
Vtest409 BL7 NM409 0

X410 NM410 BLB7 WL26 Vdd Gnd BC
Vtest410 BL7 NM410 0

X411 NM411 BLB7 WL27 Vdd Gnd BC
Vtest411 BL7 NM411 0

X412 NM412 BLB7 WL28 Vdd Gnd BC
Vtest412 BL7 NM412 0

X413 NM413 BLB7 WL29 Vdd Gnd BC
Vtest413 BL7 NM413 0

X414 NM414 BLB7 WL30 Vdd Gnd BC
Vtest414 BL7 NM414 0

X415 NM415 BLB7 WL31 Vdd Gnd BC
Vtest415 BL7 NM415 0

X416 NM416 BLB7 WL32 Vdd Gnd BC
Vtest416 BL7 NM416 0

X417 NM417 BLB7 WL33 Vdd Gnd BC
Vtest417 BL7 NM417 0

X418 NM418 BLB7 WL34 Vdd Gnd BC
Vtest418 BL7 NM418 0

X419 NM419 BLB7 WL35 Vdd Gnd BC
Vtest419 BL7 NM419 0

X420 NM420 BLB7 WL36 Vdd Gnd BC
Vtest420 BL7 NM420 0

X421 NM421 BLB7 WL37 Vdd Gnd BC
Vtest421 BL7 NM421 0

X422 NM422 BLB7 WL38 Vdd Gnd BC
Vtest422 BL7 NM422 0

X423 NM423 BLB7 WL39 Vdd Gnd BC
Vtest423 BL7 NM423 0

X424 NM424 BLB7 WL40 Vdd Gnd BC
Vtest424 BL7 NM424 0

X425 NM425 BLB7 WL41 Vdd Gnd BC
Vtest425 BL7 NM425 0

X426 NM426 BLB7 WL42 Vdd Gnd BC
Vtest426 BL7 NM426 0

X427 NM427 BLB7 WL43 Vdd Gnd BC
Vtest427 BL7 NM427 0

X428 NM428 BLB7 WL44 Vdd Gnd BC
Vtest428 BL7 NM428 0

X429 NM429 BLB7 WL45 Vdd Gnd BC
Vtest429 BL7 NM429 0

X430 NM430 BLB7 WL46 Vdd Gnd BC
Vtest430 BL7 NM430 0

X431 NM431 BLB7 WL47 Vdd Gnd BC
Vtest431 BL7 NM431 0

X432 NM432 BLB7 WL48 Vdd Gnd BC
Vtest432 BL7 NM432 0

X433 NM433 BLB7 WL49 Vdd Gnd BC
Vtest433 BL7 NM433 0

X434 NM434 BLB7 WL50 Vdd Gnd BC
Vtest434 BL7 NM434 0

X435 NM435 BLB7 WL51 Vdd Gnd BC
Vtest435 BL7 NM435 0

X436 NM436 BLB7 WL52 Vdd Gnd BC
Vtest436 BL7 NM436 0

X437 NM437 BLB7 WL53 Vdd Gnd BC
Vtest437 BL7 NM437 0

X438 NM438 BLB7 WL54 Vdd Gnd BC
Vtest438 BL7 NM438 0

X439 NM439 BLB7 WL55 Vdd Gnd BC
Vtest439 BL7 NM439 0

X440 NM440 BLB7 WL56 Vdd Gnd BC
Vtest440 BL7 NM440 0

X441 NM441 BLB7 WL57 Vdd Gnd BC
Vtest441 BL7 NM441 0

X442 NM442 BLB7 WL58 Vdd Gnd BC
Vtest442 BL7 NM442 0

X443 NM443 BLB7 WL59 Vdd Gnd BC
Vtest443 BL7 NM443 0

X444 NM444 BLB7 WL60 Vdd Gnd BC
Vtest444 BL7 NM444 0

X445 NM445 BLB7 WL61 Vdd Gnd BC
Vtest445 BL7 NM445 0

X446 NM446 BLB7 WL62 Vdd Gnd BC
Vtest446 BL7 NM446 0

X447 NM447 BLB7 WL63 Vdd Gnd BC
Vtest447 BL7 NM447 0

X448 NM448 BLB7 WL64 Vdd Gnd BC
Vtest448 BL7 NM448 0

X449 NM449 BLB8 WL1 Vdd Gnd BC
Vtest449 BL8 NM449 0

X450 NM450 BLB8 WL2 Vdd Gnd BC
Vtest450 BL8 NM450 0

X451 NM451 BLB8 WL3 Vdd Gnd BC
Vtest451 BL8 NM451 0

X452 NM452 BLB8 WL4 Vdd Gnd BC
Vtest452 BL8 NM452 0

X453 NM453 BLB8 WL5 Vdd Gnd BC
Vtest453 BL8 NM453 0

X454 NM454 BLB8 WL6 Vdd Gnd BC
Vtest454 BL8 NM454 0

X455 NM455 BLB8 WL7 Vdd Gnd BC
Vtest455 BL8 NM455 0

X456 NM456 BLB8 WL8 Vdd Gnd BC
Vtest456 BL8 NM456 0

X457 NM457 BLB8 WL9 Vdd Gnd BC
Vtest457 BL8 NM457 0

X458 NM458 BLB8 WL10 Vdd Gnd BC
Vtest458 BL8 NM458 0

X459 NM459 BLB8 WL11 Vdd Gnd BC
Vtest459 BL8 NM459 0

X460 NM460 BLB8 WL12 Vdd Gnd BC
Vtest460 BL8 NM460 0

X461 NM461 BLB8 WL13 Vdd Gnd BC
Vtest461 BL8 NM461 0

X462 NM462 BLB8 WL14 Vdd Gnd BC
Vtest462 BL8 NM462 0

X463 NM463 BLB8 WL15 Vdd Gnd BC
Vtest463 BL8 NM463 0

X464 NM464 BLB8 WL16 Vdd Gnd BC
Vtest464 BL8 NM464 0

X465 NM465 BLB8 WL17 Vdd Gnd BC
Vtest465 BL8 NM465 0

X466 NM466 BLB8 WL18 Vdd Gnd BC
Vtest466 BL8 NM466 0

X467 NM467 BLB8 WL19 Vdd Gnd BC
Vtest467 BL8 NM467 0

X468 NM468 BLB8 WL20 Vdd Gnd BC
Vtest468 BL8 NM468 0

X469 NM469 BLB8 WL21 Vdd Gnd BC
Vtest469 BL8 NM469 0

X470 NM470 BLB8 WL22 Vdd Gnd BC
Vtest470 BL8 NM470 0

X471 NM471 BLB8 WL23 Vdd Gnd BC
Vtest471 BL8 NM471 0

X472 NM472 BLB8 WL24 Vdd Gnd BC
Vtest472 BL8 NM472 0

X473 NM473 BLB8 WL25 Vdd Gnd BC
Vtest473 BL8 NM473 0

X474 NM474 BLB8 WL26 Vdd Gnd BC
Vtest474 BL8 NM474 0

X475 NM475 BLB8 WL27 Vdd Gnd BC
Vtest475 BL8 NM475 0

X476 NM476 BLB8 WL28 Vdd Gnd BC
Vtest476 BL8 NM476 0

X477 NM477 BLB8 WL29 Vdd Gnd BC
Vtest477 BL8 NM477 0

X478 NM478 BLB8 WL30 Vdd Gnd BC
Vtest478 BL8 NM478 0

X479 NM479 BLB8 WL31 Vdd Gnd BC
Vtest479 BL8 NM479 0

X480 NM480 BLB8 WL32 Vdd Gnd BC
Vtest480 BL8 NM480 0

X481 NM481 BLB8 WL33 Vdd Gnd BC
Vtest481 BL8 NM481 0

X482 NM482 BLB8 WL34 Vdd Gnd BC
Vtest482 BL8 NM482 0

X483 NM483 BLB8 WL35 Vdd Gnd BC
Vtest483 BL8 NM483 0

X484 NM484 BLB8 WL36 Vdd Gnd BC
Vtest484 BL8 NM484 0

X485 NM485 BLB8 WL37 Vdd Gnd BC
Vtest485 BL8 NM485 0

X486 NM486 BLB8 WL38 Vdd Gnd BC
Vtest486 BL8 NM486 0

X487 NM487 BLB8 WL39 Vdd Gnd BC
Vtest487 BL8 NM487 0

X488 NM488 BLB8 WL40 Vdd Gnd BC
Vtest488 BL8 NM488 0

X489 NM489 BLB8 WL41 Vdd Gnd BC
Vtest489 BL8 NM489 0

X490 NM490 BLB8 WL42 Vdd Gnd BC
Vtest490 BL8 NM490 0

X491 NM491 BLB8 WL43 Vdd Gnd BC
Vtest491 BL8 NM491 0

X492 NM492 BLB8 WL44 Vdd Gnd BC
Vtest492 BL8 NM492 0

X493 NM493 BLB8 WL45 Vdd Gnd BC
Vtest493 BL8 NM493 0

X494 NM494 BLB8 WL46 Vdd Gnd BC
Vtest494 BL8 NM494 0

X495 NM495 BLB8 WL47 Vdd Gnd BC
Vtest495 BL8 NM495 0

X496 NM496 BLB8 WL48 Vdd Gnd BC
Vtest496 BL8 NM496 0

X497 NM497 BLB8 WL49 Vdd Gnd BC
Vtest497 BL8 NM497 0

X498 NM498 BLB8 WL50 Vdd Gnd BC
Vtest498 BL8 NM498 0

X499 NM499 BLB8 WL51 Vdd Gnd BC
Vtest499 BL8 NM499 0

X500 NM500 BLB8 WL52 Vdd Gnd BC
Vtest500 BL8 NM500 0

X501 NM501 BLB8 WL53 Vdd Gnd BC
Vtest501 BL8 NM501 0

X502 NM502 BLB8 WL54 Vdd Gnd BC
Vtest502 BL8 NM502 0

X503 NM503 BLB8 WL55 Vdd Gnd BC
Vtest503 BL8 NM503 0

X504 NM504 BLB8 WL56 Vdd Gnd BC
Vtest504 BL8 NM504 0

X505 NM505 BLB8 WL57 Vdd Gnd BC
Vtest505 BL8 NM505 0

X506 NM506 BLB8 WL58 Vdd Gnd BC
Vtest506 BL8 NM506 0

X507 NM507 BLB8 WL59 Vdd Gnd BC
Vtest507 BL8 NM507 0

X508 NM508 BLB8 WL60 Vdd Gnd BC
Vtest508 BL8 NM508 0

X509 NM509 BLB8 WL61 Vdd Gnd BC
Vtest509 BL8 NM509 0

X510 NM510 BLB8 WL62 Vdd Gnd BC
Vtest510 BL8 NM510 0

X511 NM511 BLB8 WL63 Vdd Gnd BC
Vtest511 BL8 NM511 0

X512 NM512 BLB8 WL64 Vdd Gnd BC
Vtest512 BL8 NM512 0

* Write Driver

X513 WD1 BL1 EN1 ENB1 Vdd Gnd TI
X514 WD2 BL2 EN2 ENB2 Vdd Gnd TI
X515 WD3 BL3 EN3 ENB3 Vdd Gnd TI
X516 WD4 BL4 EN4 ENB4 Vdd Gnd TI
X517 WD5 BL5 EN5 ENB5 Vdd Gnd TI
X518 WD6 BL6 EN6 ENB6 Vdd Gnd TI
X519 WD7 BL7 EN7 ENB7 Vdd Gnd TI
X520 WD8 BL8 EN8 ENB8 Vdd Gnd TI

X577 WDB1 BLB1 EN1 ENB1 Vdd Gnd TI
X578 WDB2 BLB2 EN2 ENB2 Vdd Gnd TI
X579 WDB3 BLB3 EN3 ENB3 Vdd Gnd TI
X580 WDB4 BLB4 EN4 ENB4 Vdd Gnd TI
X581 WDB5 BLB5 EN5 ENB5 Vdd Gnd TI
X582 WDB6 BLB6 EN6 ENB6 Vdd Gnd TI
X583 WDB7 BLB7 EN7 ENB7 Vdd Gnd TI
X584 WDB8 BLB8 EN8 ENB8 Vdd Gnd TI

* Pre charge

X641 BL1 BLB1 PRE1 Vdd PC
X642 BL2 BLB2 PRE2 Vdd PC
X643 BL3 BLB3 PRE3 Vdd PC
X644 BL4 BLB4 PRE4 Vdd PC
X645 BL5 BLB5 PRE5 Vdd PC
X646 BL6 BLB6 PRE6 Vdd PC
X647 BL7 BLB7 PRE7 Vdd PC
X648 BL8 BLB8 PRE8 Vdd PC

* Bitlines Capacitance

Cbl1 BL1 Gnd 'cap'
Cbl2 BL2 Gnd 'cap'
Cbl3 BL3 Gnd 'cap'
Cbl4 BL4 Gnd 'cap'
Cbl5 BL5 Gnd 'cap'
Cbl6 BL6 Gnd 'cap'
Cbl7 BL7 Gnd 'cap'
Cbl8 BL8 Gnd 'cap'

Cblb1 BLB1 Gnd 'cap'
Cblb2 BLB2 Gnd 'cap'
Cblb3 BLB3 Gnd 'cap'
Cblb4 BLB4 Gnd 'cap'
Cblb5 BLB5 Gnd 'cap'
Cblb6 BLB6 Gnd 'cap'
Cblb7 BLB7 Gnd 'cap'
Cblb8 BLB8 Gnd 'cap'

.TRAN 1p 10n

.option rawfmt="psfbin"

.IC V(X224.Q)=0 V(X224.QB)=1 V(BL4)=1 V(BLB4)=1
