*Memoria de uma bitcell

simulator lang=spice

.include '45nm_LP.pm'
.include 'TRISTATE.spi'
.include '6TBitCell.spi'
.include 'PreCharge.spi'
.include 'PassTransistor.spi'

.param VPre = 1
.param Vwd = 1
.param Vwdb = 0

.param TpPre = 0.5n
.param TpWl = 1.5n

.param cap = 15f

Vwl1 WL1 Gnd PWL 0 0 '(TpWl+2p)' 0 '(TpWl+3p)' 1 (1.5n+7p) 1 (1.5n+10p) 0
Vwl2 WL2 Gnd PWL 0 0
Vwl3 WL3 Gnd PWL 0 0

Vwdb1 WDB1 Gnd 0
Vwd1 WD1 Gnd 0
Vwdb2 WDB2 Gnd 0
Vwd2 WD2 Gnd 0
Vwdb3 WDB3 Gnd 0
Vwd3 WD3 Gnd 0

*En liga em 1  ENB em 0
Venb1 ENB1 Gnd PWL 0 1
Ven1 EN1 Gnd PWL 0 0
Venb2 ENB2 Gnd PWL 0 1
Ven2 EN2 Gnd PWL 0 0
Venb3 ENB3 Gnd PWL 0 1
Ven3 EN3 Gnd PWL 0 0

Vpre1 PRE1 Gnd PWL 0 1 '(TpPre-1p)' 1 'TpPre' 0 '(TpWl)' 0 '(TpWl+1p)' 1
Vpre2 PRE2 Gnd PWL 0 1
Vpre3 PRE3 Gnd PWL 0 0

Vvdd Vvdd Gnd 'VPre'

Vdd1 Vdd1 Gnd 1
Vdd2 Vdd2 Gnd 1
Vdd3 Vdd3 Gnd 1
Vdd4 Vdd4 Gnd 1
Vdd5 Vdd5 Gnd 1
Vdd6 Vdd6 Gnd 1
Vdd7 Vdd7 Gnd 1
Vdd8 Vdd8 Gnd 1
Vdd9 Vdd9 Gnd 1

Vgnd Gnd 0 0

*Bitcell BC BL BLB WL Gnd Vdd
X1 BL1 BLB1 WL1 Vdd1 Gnd BC
X2 BL2 BLB2 WL1 Vdd2 Gnd BC
X3 BL3 BLB3 WL1 Vdd3 Gnd BC
X4 BL1 BLB1 WL2 Vdd4 Gnd BC
X5 BL2 BLB2 WL2 Vdd5 Gnd BC
X6 BL3 BLB3 WL2 Vdd6 Gnd BC
X7 BL1 BLB1 WL3 Vdd7 Gnd BC
X8 BL2 BLB2 WL3 Vdd8 Gnd BC
X9 BL3 BLB3 WL3 Vdd9 Gnd BC

*Write Driver
X11 WD1 BL1 EN1 ENB1 Vdd1 Gnd TI
X12 WDB1 BLB1 EN1 ENB1 Vdd1 Gnd TI
X13 WD2 BL2 EN2 ENB2 Vdd2 Gnd TI
X14 WDB2 BLB2 EN2 ENB2 Vdd2 Gnd TI
X15 WD3 BL3 EN3 ENB3 Vdd3 Gnd TI
X16 WDB3 BLB3 EN3 ENB3 Vdd3 Gnd TI

*Pre Charge
X21 BL1 BLB1 PRE1 Vdd1 PC
X22 BL2 BLB2 PRE2 Vdd2 PC
X23 BL3 BLB3 PRE3 Vdd3 PC

*Bitlines Capacitance
Cbl1 BL1 Gnd 'cap'
Cblb1 BLB1 Gnd 'cap'
Cbl2 BL2 Gnd 'cap'
Cblb2 BLB2 Gnd 'cap'
Cbl3 BL3 Gnd 'cap'
Cblb3 BLB3 Gnd 'cap'
.TRAN 100p 4n

.option method=trap
.option rawfmt="psfbin"
.IC V(X1.Q)=1 V(X1.QB)=0 V(BL1)=0 V(BLB1)=1 V(BL2)=0 V(BLB2)=1 V(BL3)=0 V(BLB3)=1
